* T-051 isolated dVdt behaviour run03
.param ID=6.33e-06 CD=9.5e-10 CL=0.00047 ILIM=8.13 VBUS=11.1605
VIN vin 0 DC {VBUS}
BID 0 dv I = {ID}*min(max(({VBUS}-V(dv))/10m,0),1)
CDV dv 0 {CD} IC=0
BFET vin out I = min({ILIM}, max(10*(V(dv)-V(out)),0))
CLD out 0 {CL} IC=0
RLK out 0 1G
.tran 6.699826224328595e-07 0.0026799304897314378 0 6.699826224328595e-07 UIC
.meas tran t10 WHEN V(out)=1.1160500000000002 RISE=1
.meas tran t90 WHEN V(out)=10.044450000000001 RISE=1
.meas tran vend MAX V(out)
.meas tran ipk MAX par('min(10*(V(dv)-V(out)),8.13)')
.end
