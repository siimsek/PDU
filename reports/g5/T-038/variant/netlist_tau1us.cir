* PDU v2 (G2) full-system large-signal average netlist for ngspice.
* NOT silicon models. Behavioral, average (non-switching) representation of:
*   battery+cable -> F1 -> SMCJ33A -> LM74700/Q1 ideal diode -> CIN -> 2x LM70880 phases (peak-current
*   command, average switch) -> COUT -> common-bus isolator (comparator+latch+LM74502H+CSD19531Q5A)
*   -> VSAFE -> 2x TPS259824L (unidirectional, active current limit, UVLO, 16.9 V OVLO) -> O1 / S2E.
*   G4: + phase overcurrent trip (INA296 + TLV3601), nonlinear inductor L(i).
* All parameters come from the case deck (.param block generated by analysis/g2/sim_runner.py from
* analysis/g2/params.py + analysis/g2/design.py). The case deck must also drive these nodes:
*   vbat     battery open-circuit voltage (V)
*   io1_set  O1 load current setpoint (V == A)
*   is2_set  S2E load current setpoint (V == A)
*   fault1   1 = phase-1 high-side switch shorted, 0 = normal
*   o1_ext   external O1 short request (1 = short through RSHORT)
* Parameter IL0 sets the initial per-phase inductor current (steady-state starts use .ic from the case deck).
* Ground node is 0.

* ---------------- input path
RSRC vbat n_src {RSRC}
LCAB n_src n_cab {LCAB}
RF1 n_cab anode {RF1}
DTVS 0 vin DTVSM
.model DTVSM D(BV={TVS_BV} IBV=1m RS={TVS_RS} IS=1e-12)
* LM74700 + Q1 as forward-only resistance (reverse blocked)
BQ1 anode vin I = max(V(anode,vin),0)/{RQ1} + min(V(anode,vin),0)*1e-9
CIN vin n_cin {CIN_EFF}
RCIN n_cin 0 5m
RVINBL vin 0 100k

* ---------------- buck enable (EN/UVLO divider + hysteresis state) and soft start
BVEN ven 0 V = V(vin)*{RUV2}/({RUV1}+{RUV2})
BENS 0 ens I = 1e-3*(V(ven)>{VEN_R})*(1-V(ens)) - 1e-3*(V(ven)<({VEN_R}-{VEN_H}))*V(ens)
CENS ens 0 1n
RENS ens 0 1G
* DIAGNOSTIC ONLY (T-038): RC filter between ens and the enable comparisons
RENSF ens ensf 1000
CENSF ensf 0 1n
RENSFL ensf 0 1G
* soft start: reference ramps 0 -> VREF_FB in TSS when enabled, collapses when disabled
BSS 0 ss I = (V(ensf)>0.5) ? (1n*{VREF_FB}/{TSS})*min(max(({VREF_FB}-V(ss))/1m,0),1) : -1e-6*V(ss)
CSS ss 0 1n
RSS ss 0 1G

* ---------------- error amplifier (gm) and compensation
RFB1 vraw fb {RFB1}
RFB2 fb 0 {RFB2}
BEA 0 comp I = {GM}*(V(ss)-V(fb)) * ( (V(ss)-V(fb))>0 ? min(max((2.1-V(comp))/20m,0),1) : min(max(V(comp)/20m,0),1) ) * (V(ensf)>0.5)
REA comp 0 {REA}
RCOMP comp cmid {RCOMP}
CCOMP cmid 0 {CCOMP}
CHF comp 0 {CHF}
* per-phase average current command (A), clamped to cycle-by-cycle limit (average equivalent)
BIC icmd 0 V = min(max((V(comp)-{VCOFS})/{RI},0),{ILIM_AVG})

* ---------------- phase 1 (can be faulted: high-side switch shorted)
* diode-emulation: inductor current cannot reverse in normal operation (continuous upper clamp max(VIN, VRAW-KI*iL))
BSW1 sw1 0 V = (V(fault1)>0.5) ? V(vin) : (V(ensf)>0.5 ? min(max(V(vraw)+{KI}*(V(icmd)-i(VM1)),0),max(V(vin),V(vraw)-{KI}*i(VM1))) : V(vraw)-i(VM1)*1)
VM1 sw1 l1a 0
* input current of phase 1 (average power balance: Vsw*iL = Vin*Iin); exact iL when high-side is shorted
BIN1 vin 0 I = (V(fault1)>0.5) ? i(VM1) : V(sw1)*max(i(VM1),0)/max(V(vin),1)
* G4: nonlinear inductor L(i) = LPH*g(|i|); g from Vishay doc 34207 p.3 typical curve to 16 A, extrapolated slope
* beyond 16 A down to floor LFLOOR (VARSAYIM sweep). State variable il1 = inductor current (A).
B1L l1a l1b I = V(il1)
BIL1 0 il1 I = V(l1a,l1b)/({LPH}*max({LFLOOR}, pwl(abs(V(il1)), 0,1, 4,0.977, 8,0.924, 12,0.826, 16,0.735, 116,-1.535)))
CIL1 il1 0 1 IC={IL0}
RIL1 il1 0 1e12
RL1 l1b l1c {RDCR}
RS1 l1c vraw {RS}
* ---------------- phase 2
BSW2 sw2 0 V = (V(ensf)>0.5) ? min(max(V(vraw)+{KI}*(V(icmd)-i(VM2)),0),max(V(vin),V(vraw)-{KI}*i(VM2))) : V(vraw)-i(VM2)*1
VM2 sw2 l2a 0
BIN2 vin 0 I = V(sw2)*max(i(VM2),0)/max(V(vin),1)
B2L l2a l2b I = V(il2)
BIL2 0 il2 I = V(l2a,l2b)/({LPH}*max({LFLOOR}, pwl(abs(V(il2)), 0,1, 4,0.977, 8,0.924, 12,0.826, 16,0.735, 116,-1.535)))
CIL2 il2 0 1 IC={IL0}
RIL2 il2 0 1e12
RL2 l2b l2c {RDCR}
RS2 l2c vraw {RS}

* ---------------- output capacitor bank (lumped Ceff, ESR, ESL)
COUT vraw ncout {COUT_EFF}
RESR ncout ncl {COUT_ESR}
LESL ncl 0 {COUT_ESL}
RRAWBL vraw 0 10k

* ---------------- common-bus isolator
* precision path: comparator trip at the guaranteed-delay level (trip_max + 50 mV overdrive * k), set latch q
* G4: phase overcurrent trip (2x INA296A2-Q1 on RS1/RS2 -> 2x TLV3601 -> SN74LVC1G11 AND with the bus-OV comparator
* -> latch PRE). oct integrates to 1 V in TOC_DLY while either phase current exceeds IOC (amplifier + comparator + gate delay).
BOCT 0 oct I = (((i(VM1)>{IOC})+(i(VM2)>{IOC}))>0) ? (1n/{TOC_DLY})*min(max((1.2-V(oct))/0.05,0),1)*{EN_OC} : -1e-4*V(oct)
COCT oct 0 1n
ROCT oct 0 1G
BLAT 0 q I = 0.1*max((V(vraw)>{VTRIP_EFF})*{EN_PREC}, (V(oct)>1)*{EN_OC})*max(1-V(q),0)
CQ q 0 1n
RQL q 0 1G
* coarse OV (LM74502H OV pin divider, non-latching)
BOVR ovreq 0 V = max(V(q), (V(vraw)>{VCOARSE})*{EN_COARSE})
* LM74502H gate control: discharge to switch threshold in TDLY (total chain max), recharge in TON
BCTL 0 ctl I = (V(ovreq)>0.5) ? -(1n*0.55/{TDLY})*min(max(V(ctl)/20m,0),1) : ((V(drven)>0.5) ? (1n/{TON})*min(max((1-V(ctl))/20m,0),1) : -(1n*0.55/{TDLY})*min(max(V(ctl)/20m,0),1))
CCTL ctl 0 1n
RCTL ctl 0 1G
* EN/UVLO gating from the 5 V protection rail (rail modeled as present when VIN > 6 V)
BDRVEN drven 0 V = (V(vin)>6) ? {EN_DRV} : 0
VMISO vraw nisod 0
SISO nisod vsafe ctl 0 SWISO
.model SWISO SW(Ron={RON_ISO} Roff=1e7 Vt=0.45 Vh=0.05)
DBODY vsafe nisod DBODYM
.model DBODYM D(IS=1e-12 N=1.3 RS=10m)

* ---------------- VSAFE node
CEFIN vsafe 0 {CEFIN_EFF}
RBLS vsafe 0 {R_BLEED_SAFE}
REN1 vsafe en_ef {REN_EF1}
REN2 en_ef 0 {REN_EF2}

* ---------------- eFuse U3 (O1) and U4 (S2E): unidirectional, active current limit, UVLO, OVLO
* enable state with datasheet UVLO hysteresis (rising 1.2 V / falling 1.1 V typ, TPS25982 p.9) and 16.9 V OVLO
BEFS 0 efs I = 1e-4*(V(en_ef)>{EF_UVLO})*(V(vsafe)<{EF_OVLO})*(1-V(efs)) - 1e-4*((V(en_ef)<{EF_UVLO_F})+(V(vsafe)>{EF_OVLO}))*V(efs)
CEFS efs 0 1n
REFS efs 0 1G
BEF1 vsafe o1 I = min(max((V(efs)-0.4)/0.2,0),1)*min({ILIM_O1}, max(V(vsafe,o1),0)/{RON_EF})
BEF2 vsafe s2e I = min(max((V(efs)-0.4)/0.2,0),1)*min({ILIM_S2E}, max(V(vsafe,s2e),0)/{RON_EF})
DREV1 o1 vsafe DREVM
DREV2 s2e vsafe DREVM
.model DREVM D(IS={IS_DREV} N=1.05 RS=0.04)
CPO1 o1 0 {CPORT_O1}
CPS2 s2e 0 {CPORT_S2E}
BLO1 o1 0 I = V(io1_set)*min(max(V(o1),0)/9,1)
BLS2 s2e 0 I = V(is2_set)*min(max(V(s2e),0)/9,1)
SSHO1 o1 0 o1_ext 0 SWSH
.model SWSH SW(Ron={RSHORT} Roff=1e9 Vt=0.5 Vh=0.1)
