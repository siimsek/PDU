* G2 loop AC check ac_case2
VDC vref 0 DC 0
VAC vo vfbtop DC 0 AC 1
RFB1 vfbtop fb 130000.0
RFB2 fb 0 10200.0
GEA 0 cmp fb 0 -0.00143
REA cmp 0 10000000.0
RC cmp cmid 33200.0
CC cmid 0 1e-08
CHF cmp 0 2.2e-11
EBUF vb 0 cmp 0 1
RS1 vb n1 1
LS1 n1 n2 3.6603119755373863e-07
CS1 n2 0 1.2014333333333328e-06
GMOD 0 vout n2 0 26.666666666666668
RCM vout 0 3.3959437338734295
RLOAD vout 0 14.666666666666666
CO vout nesr 0.0003706056
RESR nesr 0 6.00125e-05
EVO vo 0 vout 0 1
.ac dec 200 10 2.5meg
.control
run
wrdata ac_case2.txt vdb(vo)-vdb(vfbtop) vp(vo)-vp(vfbtop)
.endc
.end
