* G2 case f2_hotplug_20V_full_load
* generated by analysis/g2/sim_runner.py

.param RSRC=0.05
.param LCAB=5e-07
.param RF1=0.005
.param TVS_BV=36.7
.param TVS_RS=0.590747331
.param RQ1=0.0288
.param CIN_EFF=1.88e-05
.param RUV1=174000
.param RUV2=10000
.param VEN_R=1
.param VEN_H=0.1
.param LFLOOR=0.15
.param IOC=13.5996661
.param TOC_DLY=1.5123e-06
.param EN_OC=1
.param TSS=0.003
.param VREF_FB=0.8
.param RFB1=130000
.param RFB2=10200
.param GM=0.0012
.param REA=10000000
.param RCOMP=33200
.param CCOMP=1e-08
.param CHF=2.2e-11
.param VCOFS=0
.param RI=0.075
.param ILIM_AVG=6.16666667
.param KI=4.272566
.param LPH=6.8e-06
.param RDCR=0.0233
.param RS=0.0075
.param COUT_EFF=0.000659904
.param COUT_ESR=6.00125e-05
.param COUT_ESL=1.5625e-11
.param VTRIP_EFF=11.7646503
.param VCOARSE=13.7377754
.param EN_PREC=1
.param EN_COARSE=1
.param TDLY=1.04826729e-06
.param TON=7.5e-06
.param EN_DRV=1
.param RON_ISO=0.01152
.param CEFIN_EFF=1e-07
.param R_BLEED_SAFE=4700
.param REN_EF1=64900
.param REN_EF2=10000
.param EF_UVLO=1.2
.param EF_UVLO_F=1.1
.param EF_OVLO=16.9
.param ILIM_O1=8.13
.param ILIM_S2E=4.98
.param RON_EF=0.0048
.param IS_DREV=2e-05
.param IL0=0
.param CPORT_O1=4e-06
.param CPORT_S2E=4e-06
.param RSHORT=0.01
.param TSTOP=0.008

VBAT vbat 0 PWL(0 0 5e-05 0 5.1e-05 20.0)
VIO1 io1_set 0 6.78
VIS2 is2_set 0 0.22
VFLT fault1 0 0
VO1X o1_ext 0 0
.include ../../../../design/pdu_v2.cir

BVDS vds 0 V = V(vraw)-V(vsafe)
BO1IN o1in 0 V = V(o1)-V(vsafe)
BS2IN s2ein 0 V = V(s2e)-V(vsafe)
BPD pdiss 0 V = V(vraw,vsafe)*i(VMISO)
.tran 5e-07 0.008 0 5e-07 uic
.options method=gear reltol=1e-4 abstol=1e-9 vntol=1e-6 itl4=200
.meas tran vin_max MAX V(vin)
.meas tran vraw_max MAX V(vraw)
.meas tran vraw_end FIND V(vraw) AT=0.008
.meas tran vraw_end_hi FIND V(vraw) AT=0.008
.meas tran q_end FIND V(q) AT=0.008
.meas tran ens_end FIND V(ens) AT=0.008
.meas tran o1_end FIND V(o1) AT=0.008
.meas tran s2e_end FIND V(s2e) AT=0.008
.end
