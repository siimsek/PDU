* Acik cevrim asenkron buck guc kati - araclar.py tarafindan uretildi
* vin=26.0 f=100000.0 duty=0.43224443285384617 full=True startup=False
Vbat bat 0 26
Rsrc bat n1 0.02
Lsrc n1 vin 3e-07 Rser=1m
Cin vin 0 0.00022 Rser=0.0111 Lser=4.9e-09 m=2
Lbulk vin vinh 5e-09 Rser=0.5m
Cmlcc vinh 0 4.7e-06 Rser=0.003 Lser=8e-10 m=2
Lloop vinh d 3e-09 Rser=0.5m
M1 d g sw sw BSZ065N06LS5
Vdrv gp sw PULSE(0 10 0 1e-08 1e-08 4.31244e-06 1e-05)
Rg gp g 10
D1 0 sw RBR40NS60A
L1 sw out 3.3e-05 Rser=0.00133 Rpar=1543 Cpar=1.84e-11
Cout out 0 0.00033 Rser=0.0092 Lser=5.9e-09 m=1
Rload out 0 1.46667
Rsn sw nsn 2.2
Csn nsn 0 1e-09 Lser=0.5n
Coutm out 0 8u Rser=3m Lser=0.8n m=2

* 20 MHz olcum bant siniri (osiloskop BW limit esdegeri); devreyi yuklemez
Ebw nbw 0 out 0 1
Rbw nbw outbw 1k
Cbw outbw 0 7.96p
.ic V(out)=11.0 I(L1)=7.5 V(vin)=25.9365 I(Lsrc)=3.17308
.lib standard.mos
.lib standard.dio
.temp 27
.options maxstep=2e-08
.tran 0 0.006 0.004 uic

.meas tran vo avg V(out) FROM 0.005 TO 0.006
.meas tran voprev avg V(out) FROM 0.004 TO 0.005
.meas tran pin avg V(vin)*I(Lsrc) FROM 0.005 TO 0.006
.meas tran pout avg V(out)*I(Rload) FROM 0.005 TO 0.006
.meas tran pgate avg -V(gp,sw)*I(Vdrv) FROM 0.005 TO 0.006
.meas tran pmos avg V(d,sw)*Id(M1)+V(g,sw)*Ig(M1) FROM 0.005 TO 0.006
.meas tran pdio avg -V(sw)*I(D1) FROM 0.005 TO 0.006
.meas tran pind avg V(sw,out)*I(L1) FROM 0.005 TO 0.006
.meas tran pcin avg V(vin)*I(Cin) FROM 0.005 TO 0.006
.meas tran pcout avg V(out)*I(Cout) FROM 0.005 TO 0.006
.meas tran ilavg avg I(L1) FROM 0.005 TO 0.006
.meas tran ilmax max I(L1) FROM 0.005 TO 0.006
.meas tran ilmin min I(L1) FROM 0.005 TO 0.006
.meas tran ilrms rms I(L1) FROM 0.005 TO 0.006
.meas tran icinrms rms I(Cin) FROM 0.005 TO 0.006
.meas tran icoutrms rms I(Cout) FROM 0.005 TO 0.006
.meas tran vopp pp V(out) FROM 0.005 TO 0.006
.meas tran vopp20 pp V(outbw) FROM 0.005 TO 0.006
.meas tran vinpp pp V(vin) FROM 0.005 TO 0.006
.meas tran vomax max V(out) FROM 0.005 TO 0.006
.meas tran vdsmax max V(d,sw) FROM 0.005 TO 0.006
.meas tran vgsmax max V(g,sw) FROM 0.005 TO 0.006
.meas tran vgsmin min V(g,sw) FROM 0.005 TO 0.006
.meas tran vrmax max V(sw) FROM 0.005 TO 0.006
.meas tran vswmin min V(sw) FROM 0.005 TO 0.006
.meas tran idmax max Id(M1) FROM 0.005 TO 0.006
.meas tran idrms rms Id(M1) FROM 0.005 TO 0.006
.meas tran idioavg avg I(D1) FROM 0.005 TO 0.006
.meas tran iinavg avg I(Lsrc) FROM 0.005 TO 0.006
.meas tran iinmax max I(Lsrc) FROM 0.005 TO 0.006
.end
