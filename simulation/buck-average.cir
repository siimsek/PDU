* IDA PDU - generic averaged buck training model, not LM70880 macro-model
.param VIN=20
.step param VIN list 20 22.2 25.2 26
V1 in 0 {VIN}
Bsw sw 0 V=V(in)*V(duty)
L1 sw out 6.8u Rser=10m
C1 out 0 132u Rser=3m
Bint 0 integ I=300*(11-V(out))
Cint integ 0 1 IC=0
Bduty duty 0 V=limit(0.12*(11-V(out))+V(integ),0,0.9)
Bload out 0 I=if(time<5m,0.75,7.5)
.ic V(out)=0 V(integ)=0
.tran 0 15m 0 100n startup
.meas tran VOUT_AVG AVG V(out) FROM=12m TO=15m
.meas tran VOUT_MIN MIN V(out) FROM=12m TO=15m
.meas tran VOUT_MAX MAX V(out) FROM=12m TO=15m
.meas tran IL_MAX MAX I(L1) FROM=12m TO=15m
.meas tran IL_MIN MIN I(L1) FROM=12m TO=15m
.options plotwinsize=0
.end
