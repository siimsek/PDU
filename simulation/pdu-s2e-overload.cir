* PDU full-connectivity BEHAVIORAL bench: s2e-overload; NOT vendor silicon.
.include pdu-protection.inc
.include pdu-inductor-lt.lib
.param CBIAS=0.5 LFACTOR=1
Vbattery VOUT 0 PWL(0 0 100u 11)
Bload1 O1_11V 0 I=(3)*min(max(V(O1_11V)/5,0),1)
Bload2 S2E_11V 0 I=(if(time<15m,1.5,3))*min(max(V(S2E_11V)/5,0),1)
Rbleed VOUT 0 100k

.tran 100n 40m 0 1u uic
.options reltol=0.0001 abstol=1n method=gear
.meas tran FAULT_OFF MAX V(S2E_11V) FROM=20m TO=40m
.meas tran HEALTHY AVG V(O1_11V) FROM=35m TO=40m
.options plotwinsize=0
.save V(O1_11V) V(S2E_11V)
.end
