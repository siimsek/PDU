* IDA PDU average current-mode load step. Equation-42 plant only.
* Two phases share COMP. No switch ripple, no sampling poles, no LM70880 silicon.
* Ceff is the 88 uF assumption. RS is 7.5 mOhm per phase, GCS is 10.
Biea 0 comp I=1200u*(0.8-V(fb))
Roea comp 0 64Meg
Cbw comp 0 38p
Rcomp comp mid 9.53k
Ccomp mid 0 4.7n
Chf comp 0 47p
Rfb1 out fb 130k
Rfb2 fb 0 10.2k
Bi1 0 out I=limit(V(comp)/(7.5m*10),0,8)
Bi2 0 out I=limit(V(comp)/(7.5m*10),0,8)
Cout out 0 88u
Iload out 0 PWL(0 0.75 1.999m 0.75 2m 7.5 5m 7.5)
.ic V(out)=11 V(comp)=0.28125 V(fb)=0.8
.tran 0 5m 0 2u
.meas tran VOUT_SETTLED AVG V(out) FROM=4m TO=5m
.meas tran VOUT_MIN MIN V(out) FROM=2m TO=5m
.meas tran VOUT_MAX MAX V(out) FROM=2m TO=5m
.meas tran VCOMP FIND V(comp) AT=4.5m
.meas tran IPHASE FIND I(Bi1) AT=4.5m
.options plotwinsize=0 measdgt=8
.end
