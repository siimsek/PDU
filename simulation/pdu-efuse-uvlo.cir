* PDU full-connectivity BEHAVIORAL bench: efuse-uvlo; NOT vendor silicon.
.include pdu-protection.inc
.include pdu-inductor-lt.lib
.param CBIAS=0.5 LFACTOR=1
Vbattery VOUT 0 PWL(0 0 100u 10 10m 10 10.1m 8.6 20m 8.6 20.1m 8 30m 8 30.1m 10)
Bload1 O1_11V 0 I=(3)*min(max(V(O1_11V)/5,0),1)
Bload2 S2E_11V 0 I=(1.5)*min(max(V(S2E_11V)/5,0),1)
Rbleed VOUT 0 100k

.tran 100n 40m 0 1u uic
.options reltol=0.0001 abstol=1n method=gear
.meas tran O1_HOLD AVG V(O1_11V) FROM=15m TO=19m
.meas tran O1_OFF MAX V(O1_11V) FROM=25m TO=29m
.meas tran O1_RESET AVG V(O1_11V) FROM=35m TO=40m
.options plotwinsize=0
.save V(O1_11V)
.end
