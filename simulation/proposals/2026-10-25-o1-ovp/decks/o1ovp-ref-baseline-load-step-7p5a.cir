* WP1 2026-10-25-o1-ovp proposal bench (BEHAVIORAL/IDEAL models; NOT vendor silicon). Generated by gen_o1ovp.py.
* REFERENCE ONLY: unmodified baseline circuit, 0.75->7.5 A step (shows buck-only response).
.include ../../../pdu-circuit.inc
.include ../../../pdu-inductor-lt.lib
.param CBIAS=0.5 LFACTOR=1
Vbattery VBAT 0 PWL(0 0 100u 20)
Bload1 O1_11V 0 I=(if(time<20m,0.3,3))*min(max(V(O1_11V)/5,0),1)
Bload2 S2E_11V 0 I=(if(time<20m,0.15,1.5))*min(max(V(S2E_11V)/5,0),1)
Bextra VOUT 0 I=(if(time<20m,0.3,3))*min(max(V(VOUT)/5,0),1)
Rbleed VOUT 0 100k
.tran 100n 40m 0 1u uic
.options reltol=0.0001 abstol=1n method=gear
.meas tran BUS_MIN MIN V(VOUT) FROM=20m TO=22m
.meas tran BUS_MAX MAX V(VOUT) FROM=20m TO=22m
.options plotwinsize=0
.save V(VOUT)
.end
