* WP1 2026-10-25-o1-ovp proposal bench (BEHAVIORAL/IDEAL models; NOT vendor silicon). Generated by gen_o1ovp.py.
* buck high-side short to 26 V (style of build_global_ovp_candidates.py); RAW Ceff=120u, bank ESR=12.5m.
* Ideal DRIVE replaces the buck; 2.72 uH + 15.4 mOhm to RAW. All 7.5 A of load removed at fault onset.
* Bus load Bextra ramps in over 16-18 ms: the unregulated bench LC (Z0=0.17 ohm) would otherwise ring RAW
* above the trip on the 3 A turn-on step (bench artifact, not a buck behaviour). Fault removal is a 1 ms ramp
* (45-46 ms) because an ideal 10 ns 26->11 V step rings RAW below 0 V; acceptance windows are unchanged.
.include ../../../pdu-behavioral.lib
.include ../../../pdu-inductor-ng.lib
.include ../pdu-o1ovp-behavioral.lib
.include ../pdu-efuse-block-o1ovp.inc
.include ../pdu-o1ovp-block.inc
.param TDON=1.68u TDOV=5.55u IBST=345u IPU=1.69 IPD=2 VTH_P=1.5 CGS_P=5n NPAR=2 RON_P=1.8m CRAW=120u ESR=12.5m VBSTR=9 VCPOFF=11.6 VREF_P=4.105424 RT_P=2054.1 RB_P=1147.7 CMP_VTRIP=64.1m CMP_VREL=62.6m CMP_IB=5u TDOFF=1.0545u
Vaux VIN 0 26
Vsource DRIVE 0 PWL(0 0 5m 11.1605 30m 11.1605 30.00001m 26 45m 26 46m 11.1605 50m 11.1605 50.1m 0 55m 0 60m 11.1605)
Lfault DRIVE LF 2.72u
RfaultDCR LF RAW 0.0154
Craw RAW_C 0 {CRAW}
Resr RAW RAW_C {ESR}
Bload1 O1_11V 0 I=(if(time<30m,3,if(time<50m,0,3)))*min(max(V(O1_11V)/5,0),1)
Bload2 S2E_11V 0 I=(if(time<30m,1.5,if(time<50m,0,1.5)))*min(max(V(S2E_11V)/5,0),1)
Bextra VOUT 0 I=(if(time<30m,3,if(time<50m,0,3)))*min(max((time-16m)/2m,0),1)*min(max(V(VOUT)/5,0),1)
Rbleed VOUT 0 100k
.tran 100n 80m 0 100n uic
.options reltol=0.0001 abstol=1n method=gear
.meas tran NORMAL AVG V(VOUT) FROM=24m TO=29m
.meas tran O1_NORMAL AVG V(O1_11V) FROM=24m TO=29m
.meas tran O1_PEAK MAX V(O1_11V) FROM=29m TO=45m
.meas tran BUS_PEAK MAX V(VOUT) FROM=29m TO=45m
.meas tran RAW_PEAK MAX V(RAW) FROM=29m TO=45m
.meas tran VDSA_MAX MAX V(M_VDSA) FROM=29m TO=45m
.meas tran VDSB_MAX MAX V(M_VDSB) FROM=29m TO=45m
.meas tran S2E_PEAK MAX V(S2E_11V) FROM=29m TO=45m
.meas tran INM_MAX MAX V(INM_OVP) FROM=29m TO=45m
.meas tran IINM_MAX MAX V(M_IINM) FROM=29m TO=45m
.meas tran V5_MAX MAX V(V5_OVP) FROM=29m TO=45m
.meas tran INP_FAULT_MAX MAX V(INP_OVP) FROM=30.01m TO=45m
.meas tran TRIP_RAW FIND V(RAW) WHEN V(INP_OVP)=2.5 TD=29m FALL=1
.meas tran OFF_RAW FIND V(RAW) WHEN V(M_VGS)=1 TD=29m FALL=1
.meas tran O1_RESET AVG V(O1_11V) FROM=75m TO=80m
.meas tran S2E_RESET AVG V(S2E_11V) FROM=75m TO=80m
.options plotwinsize=0
.save V(O1_11V) V(S2E_11V) V(VOUT) V(RAW) V(INP_OVP) V(M_VGS) V(M_VDSA) V(M_VDSB) V(V5_OVP) V(INM_OVP) V(M_IINM)
.end
