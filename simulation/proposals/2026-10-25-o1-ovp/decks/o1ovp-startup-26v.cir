* WP1 2026-10-25-o1-ovp proposal bench (BEHAVIORAL/IDEAL models; NOT vendor silicon). Generated by gen_o1ovp.py.
* full board startup-26v; RAW split circuit + OVP block. Corner wclo {'CBIAS': '0.5', 'LFACTOR': '1'}.
.include ../../../pdu-behavioral.lib
.include ../../../pdu-inductor-lt.lib
.include ../pdu-o1ovp-behavioral.lib
.include ../pdu-circuit-o1ovp.inc
.include ../pdu-o1ovp-block.inc
.param TDON=1.68u TDOV=5.55u IBST=345u IPU=1.69 IPD=2 VTH_P=1.5 CGS_P=5n NPAR=2 RON_P=1.8m CRAW=92.65u ESR=1m VBSTR=9 VCPOFF=11.6 VREF_P=4.086576 RT_P=2045.9 RB_P=1152.3 CMP_VTRIP=-9.1m CMP_VREL=-14.1m CMP_IB=-5u TDOFF=1.0545u CBIAS=0.5 LFACTOR=1
Vbattery VBAT 0 PWL(0 0 100u 26)
Bload1 O1_11V 0 I=(3)*min(max(V(O1_11V)/5,0),1)
Bload2 S2E_11V 0 I=(1.5)*min(max(V(S2E_11V)/5,0),1)
Rbleed VOUT 0 100k
.tran 100n 40m 0 1u uic
.options reltol=0.0001 abstol=1n method=gear
Bmeasure1 M_ISNS1 0 V=V(ISNS1,RAW)/0.0075
Bmeasure2 M_ISNS2 0 V=V(ISNS2,RAW)/0.0075
.meas tran BUS_AVG AVG V(VOUT) FROM=35m TO=40m
.meas tran RAW_AVG AVG V(RAW) FROM=35m TO=40m
.meas tran O1_AVG AVG V(O1_11V) FROM=35m TO=40m
.meas tran S2E_AVG AVG V(S2E_11V) FROM=35m TO=40m
.meas tran IPHASE1_AVG AVG V(M_ISNS1) FROM=35m TO=40m
.meas tran IPHASE2_AVG AVG V(M_ISNS2) FROM=35m TO=40m
.meas tran PG1_MAX MAX V(PG_O1) FROM=0 TO=40m
.meas tran PG2_MAX MAX V(PG_S2E) FROM=0 TO=40m
.meas tran IMON1_AVG AVG V(IMON_O1) FROM=35m TO=40m
.meas tran IMON2_AVG AVG V(IMON_S2E) FROM=35m TO=40m
.meas tran RAW_MAX MAX V(RAW) FROM=0 TO=40m
.meas tran BUS_MAX MAX V(VOUT) FROM=0 TO=40m
.meas tran O1_MAX MAX V(O1_11V) FROM=0 TO=40m
.meas tran VDSB_MAX MAX V(M_VDSB) FROM=0 TO=40m
.meas tran FET_ON_T WHEN V(M_VGS)=6 RISE=1
.meas tran INP_MIN MIN V(INP_OVP) FROM=20m TO=40m
.meas tran VGS_MIN MIN V(M_VGS) FROM=20m TO=40m
.options plotwinsize=0
.save V(VOUT) V(RAW) V(O1_11V) V(S2E_11V) V(PG_O1) V(PG_S2E) V(IMON_O1) V(IMON_S2E) V(M_ISNS1) V(M_ISNS2) V(INP_OVP) V(M_VGS) V(M_VDSA) V(M_VDSB) V(V5_OVP) V(INM_OVP) V(M_IINM)
.end
