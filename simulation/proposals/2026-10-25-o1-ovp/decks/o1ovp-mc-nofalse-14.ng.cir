* WP1 2026-10-25-o1-ovp proposal bench (BEHAVIORAL/IDEAL models; NOT vendor silicon). Generated by gen_o1ovp.py.
* no-false-trip bench MC#14: RAW = 11.1605 V static max + 10 mV/870 kHz ripple until 20 ms, then
* 11.21 V DC + 10 mV ripple (peak 11.22 V = upper bus limit); 7.5 A load; lowest-trip corner.
* Ripple amplitude: 2-phase interleaved buck, 2.14 A pp/phase into >=185.3 uF ceramic (rev2) -> a few mV; 10 mV is
* used as margin. (The 2026-10-24 59.5 mV/800 kHz deck forced 10 uF*dV/dt = 3 A into CEFOUT and tripped the
* PDU_EFUSE breaker - a bench artifact, not an OVP false trip.) Pass = comparator/FETs never turn off.
.include ../../../pdu-behavioral.lib
.include ../../../pdu-inductor-ng.lib
.include ../pdu-o1ovp-behavioral.lib
.include ../pdu-efuse-block-o1ovp.inc
.include ../pdu-o1ovp-block.inc
.param TDON=1.68u TDOV=5.55u IBST=555u IPU=1.69 IPD=2 VTH_P=1.5 CGS_P=5n NPAR=2 RON_P=1.8m CRAW=185.3u ESR=1m VBSTR=9 VCPOFF=11.6 VREF_P=4.098407 RT_P=2048.85 RB_P=1149.04 CMP_VTRIP=0.00362142 CMP_VREL=-0.000681808 CMP_IB=-4.684e-06 TDOFF=7.0574e-07
Vaux VIN 0 PWL(0 0 100u 20)
Vbattery RAWDC 0 PWL(0 0 100u 11.1605 20m 11.1605 20.1m 11.21 30m 11.21)
Vripple RAW RAWDC SIN(0 10m 870k 0 0 0)
Bload1 O1_11V 0 I=(3)*min(max(V(O1_11V)/5,0),1)
Bload2 S2E_11V 0 I=(1.5)*min(max(V(S2E_11V)/5,0),1)
Bextra VOUT 0 I=3*min(max(V(VOUT)/5,0),1)
Rbleed VOUT 0 100k
.tran 20n 30m 0 50n uic
.options reltol=0.0001 abstol=1n method=gear
.meas tran RAW_MAX MAX V(RAW) FROM=12m TO=30m
.meas tran O1_AVG AVG V(O1_11V) FROM=25m TO=30m
.meas tran S2E_AVG AVG V(S2E_11V) FROM=25m TO=30m
.meas tran BUS_MIN MIN V(VOUT) FROM=12m TO=30m
.meas tran O1_GLOBAL_PEAK MAX V(O1_11V) FROM=0 TO=30m
.meas tran INP_MIN MIN V(INP_OVP) FROM=12m TO=30m
.meas tran VGS_MIN MIN V(M_VGS) FROM=12m TO=30m
.options plotwinsize=0
.save V(RAW) V(VOUT) V(O1_11V) V(S2E_11V) V(INP_OVP) V(M_VGS) V(M_VDSA) V(M_VDSB) V(V5_OVP) V(INM_OVP) V(M_IINM)
.end
