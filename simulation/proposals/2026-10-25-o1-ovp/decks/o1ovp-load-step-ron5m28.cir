* WP1 2026-10-25-o1-ovp proposal bench (BEHAVIORAL/IDEAL models; NOT vendor silicon). Generated by gen_o1ovp.py.
* full board load-step 0.45->4.5A ron5m28; RAW split circuit + OVP block. Corner wclo {'CBIAS': '0.5', 'LFACTOR': '1', 'RON_P': '5.28m'}.
.include ../../../pdu-behavioral.lib
.include ../../../pdu-inductor-lt.lib
.include ../pdu-o1ovp-behavioral.lib
.include ../pdu-circuit-o1ovp.inc
.include ../pdu-o1ovp-block.inc
.param TDON=1.68u TDOV=5.55u IBST=345u IPU=1.69 IPD=2 VTH_P=1.5 CGS_P=5n NPAR=2 RON_P=5.28m CRAW=185.3u ESR=1m VBSTR=9 VCPOFF=11.6 VREF_P=4.086576 RT_P=2045.9 RB_P=1152.3 CMP_VTRIP=-9.1m CMP_VREL=-14.1m CMP_IB=-5u TDOFF=1.0545u CBIAS=0.5 LFACTOR=1
Vbattery VBAT 0 PWL(0 0 100u 20)
Bload1 O1_11V 0 I=(if(time<20m,0.3,3))*min(max(V(O1_11V)/5,0),1)
Bload2 S2E_11V 0 I=(if(time<20m,0.15,1.5))*min(max(V(S2E_11V)/5,0),1)
Rbleed VOUT 0 100k
.tran 100n 40m 0 1u uic
.options reltol=0.0001 abstol=1n method=gear
Bmeasure1 M_ISNS1 0 V=V(ISNS1,RAW)/0.0075
Bmeasure2 M_ISNS2 0 V=V(ISNS2,RAW)/0.0075
.meas tran BUS_MIN MIN V(VOUT) FROM=20m TO=22m
.meas tran BUS_MAX MAX V(VOUT) FROM=20m TO=22m
.meas tran RAW_MIN MIN V(RAW) FROM=20m TO=22m
.meas tran O1_FINAL AVG V(O1_11V) FROM=35m TO=40m
.meas tran S2E_FINAL AVG V(S2E_11V) FROM=35m TO=40m
.meas tran INP_MIN MIN V(INP_OVP) FROM=15m TO=40m
.meas tran VGS_MIN MIN V(M_VGS) FROM=15m TO=40m
.options plotwinsize=0
.save V(VOUT) V(RAW) V(O1_11V) V(S2E_11V) V(PG_O1) V(PG_S2E) V(IMON_O1) V(IMON_S2E) V(M_ISNS1) V(M_ISNS2) V(INP_OVP) V(M_VGS) V(M_VDSA) V(M_VDSB) V(V5_OVP) V(INM_OVP) V(M_IINM)
.end
