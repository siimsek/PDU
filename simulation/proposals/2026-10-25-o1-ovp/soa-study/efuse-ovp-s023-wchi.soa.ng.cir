* SOA-STUDY COPY of decks/o1ovp-efuse-ovp-s023-wchi.ng.cir (probes appended only) - information, NOT acceptance
* WP1 2026-10-25-o1-ovp proposal bench (BEHAVIORAL/IDEAL models; NOT vendor silicon). Generated by gen_o1ovp.py.
* efuse-ovp ramp s023 (0.23 V/us) corner wchi {}. Baseline PWL 11->18 V applied to RAW (upstream of
* the new FETs) instead of VOUT. IBST=555u (max) only so the board is in steady state before 15 ms.
.include ../../../pdu-behavioral.lib
.include ../../../pdu-inductor-ng.lib
.include ../pdu-o1ovp-behavioral.lib
.include ../pdu-efuse-block-o1ovp.inc
.include ../pdu-o1ovp-block.inc
.param TDON=1.68u TDOV=5.55u IBST=555u IPU=1.69 IPD=2 VTH_P=1.5 CGS_P=5n NPAR=2 RON_P=1.8m CRAW=185.3u ESR=1m VBSTR=9 VCPOFF=11.6 VREF_P=4.105424 RT_P=2054.1 RB_P=1147.7 CMP_VTRIP=64.1m CMP_VREL=62.6m CMP_IB=5u TDOFF=1.0545u
Vaux VIN 0 PWL(0 0 100u 20)
Vbattery RAW 0 PWL(0 0 100u 11 15m 11 0.0150304348 18 25m 18 25.1m 11)
Bload1 O1_11V 0 I=(3)*min(max(V(O1_11V)/5,0),1)
Bload2 S2E_11V 0 I=(1.5)*min(max(V(S2E_11V)/5,0),1)
Rbleed VOUT 0 100k
.tran 100n 40m 0 100n uic
.options reltol=0.0001 abstol=1n method=gear
.meas tran O1_PRE AVG V(O1_11V) FROM=13m TO=14.9m
.meas tran O1_OFF MAX V(O1_11V) FROM=19m TO=24m
.meas tran S2E_OFF MAX V(S2E_11V) FROM=19m TO=24m
.meas tran O1_RESET AVG V(O1_11V) FROM=35m TO=40m
.meas tran S2E_RESET AVG V(S2E_11V) FROM=35m TO=40m
.meas tran O1_PEAK MAX V(O1_11V) FROM=14m TO=19m
.meas tran BUS_PEAK MAX V(VOUT) FROM=14m TO=19m
.meas tran TRIP_RAW FIND V(RAW) WHEN V(INP_OVP)=2.5 TD=14m FALL=1
.meas tran OFF_RAW FIND V(RAW) WHEN V(M_VGS)=1 TD=14m FALL=1
.meas tran S2E_PEAK MAX V(S2E_11V) FROM=14m TO=19m
.meas tran VDSA_MAX MAX V(M_VDSA) FROM=14m TO=26m
.meas tran INM_MAX MAX V(INM_OVP) FROM=14m TO=26m
.meas tran IINM_MAX MAX V(M_IINM) FROM=14m TO=26m
.meas tran V5_MAX MAX V(V5_OVP) FROM=14m TO=26m
.meas tran INP_FAULT_MAX MAX V(INP_OVP) FROM=17m TO=25m
.meas tran BUS_PRE_MAX MAX V(VOUT) FROM=0 TO=14.9m
.meas tran O1_PRE_MAX MAX V(O1_11V) FROM=0 TO=14.9m
.meas tran INP_PRE_MIN MIN V(INP_OVP) FROM=13m TO=14.9m
.meas tran VGS_PRE_MIN MIN V(M_VGS) FROM=13m TO=14.9m
.meas tran BUS_RECOV_MAX MAX V(VOUT) FROM=25.1m TO=40m
.meas tran O1_RECOV_MAX MAX V(O1_11V) FROM=25.1m TO=40m
.meas tran INP_RECOV_MIN MIN V(INP_OVP) FROM=25.1m TO=40m
.meas tran VGS_RECOV_MIN MIN V(M_VGS) FROM=25.1m TO=40m
.meas tran INFO_STARTUP_INP_MIN MIN V(INP_OVP) FROM=1m TO=13m
.meas tran INFO_STARTUP_VGS_FALL_T WHEN V(M_VGS)=6 FALL=1
.meas tran O1_GLOBAL_PEAK MAX V(O1_11V) FROM=0 TO=40m
.options plotwinsize=0
.save V(O1_11V) V(S2E_11V) V(VOUT) V(RAW) V(INP_OVP) V(M_VGS) V(M_VDSA) V(M_VDSB) V(V5_OVP) V(INM_OVP) V(M_IINM)
* --- SOA study probes (appended; circuit unchanged) ---
Bga M_GA 0 V=(1n+min(max((V(G_OVP,SRC_OVP)-{VTH_P})/(4.5-{VTH_P}),0),1)/{RON_P/NPAR})
Bia M_IA 0 V=V(RAW,SRC_OVP)*V(M_GA)
Bib M_IB 0 V=V(VOUT,SRC_OVP)*V(M_GA)
Bpa M_PA 0 V=V(RAW,SRC_OVP)*V(M_IA)
Bpb M_PB 0 V=V(VOUT,SRC_OVP)*V(M_IB)
.meas tran startup_PA_MAX MAX V(M_PA) FROM=0 TO=14.9m
.meas tran startup_EA INTEG V(M_PA) FROM=0 TO=14.9m
.meas tran startup_IA_MAX MAX V(M_IA) FROM=0 TO=14.9m
.meas tran startup_IA_MIN MIN V(M_IA) FROM=0 TO=14.9m
.meas tran startup_VA_MAX MAX V(M_VDSA) FROM=0 TO=14.9m
.meas tran startup_VA_MIN MIN V(M_VDSA) FROM=0 TO=14.9m
.meas tran startup_PB_MAX MAX V(M_PB) FROM=0 TO=14.9m
.meas tran startup_EB INTEG V(M_PB) FROM=0 TO=14.9m
.meas tran startup_IB_MAX MAX V(M_IB) FROM=0 TO=14.9m
.meas tran startup_IB_MIN MIN V(M_IB) FROM=0 TO=14.9m
.meas tran startup_VB_MAX MAX V(M_VDSB) FROM=0 TO=14.9m
.meas tran startup_VB_MIN MIN V(M_VDSB) FROM=0 TO=14.9m
.meas tran fault_PA_MAX MAX V(M_PA) FROM=14.9m TO=25.1m
.meas tran fault_EA INTEG V(M_PA) FROM=14.9m TO=25.1m
.meas tran fault_IA_MAX MAX V(M_IA) FROM=14.9m TO=25.1m
.meas tran fault_IA_MIN MIN V(M_IA) FROM=14.9m TO=25.1m
.meas tran fault_VA_MAX MAX V(M_VDSA) FROM=14.9m TO=25.1m
.meas tran fault_VA_MIN MIN V(M_VDSA) FROM=14.9m TO=25.1m
.meas tran fault_PB_MAX MAX V(M_PB) FROM=14.9m TO=25.1m
.meas tran fault_EB INTEG V(M_PB) FROM=14.9m TO=25.1m
.meas tran fault_IB_MAX MAX V(M_IB) FROM=14.9m TO=25.1m
.meas tran fault_IB_MIN MIN V(M_IB) FROM=14.9m TO=25.1m
.meas tran fault_VB_MAX MAX V(M_VDSB) FROM=14.9m TO=25.1m
.meas tran fault_VB_MIN MIN V(M_VDSB) FROM=14.9m TO=25.1m
.meas tran recovery_PA_MAX MAX V(M_PA) FROM=25.1m TO=40m
.meas tran recovery_EA INTEG V(M_PA) FROM=25.1m TO=40m
.meas tran recovery_IA_MAX MAX V(M_IA) FROM=25.1m TO=40m
.meas tran recovery_IA_MIN MIN V(M_IA) FROM=25.1m TO=40m
.meas tran recovery_VA_MAX MAX V(M_VDSA) FROM=25.1m TO=40m
.meas tran recovery_VA_MIN MIN V(M_VDSA) FROM=25.1m TO=40m
.meas tran recovery_PB_MAX MAX V(M_PB) FROM=25.1m TO=40m
.meas tran recovery_EB INTEG V(M_PB) FROM=25.1m TO=40m
.meas tran recovery_IB_MAX MAX V(M_IB) FROM=25.1m TO=40m
.meas tran recovery_IB_MIN MIN V(M_IB) FROM=25.1m TO=40m
.meas tran recovery_VB_MAX MAX V(M_VDSB) FROM=25.1m TO=40m
.meas tran recovery_VB_MIN MIN V(M_VDSB) FROM=25.1m TO=40m
.end
