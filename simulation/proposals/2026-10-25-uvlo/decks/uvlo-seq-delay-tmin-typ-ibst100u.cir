* WP2 2026-10-25-uvlo proposal bench (BEHAVIORAL/IDEAL models; NOT vendor silicon). Generated by gen_uvlo.py.
* ngspice-44.2 only (run with -D ngbehavior=ltpsa). LTspice: bulut ortaminda calistirilmadi.
* P0-03 sequencing bench seq-delay-tmin-typ-ibst100u: WP1 ESL bench (Vaux VIN 26 V from t=0, ideal DRIVE 0->11.1605 V starting at
* t = 77.824 ms (= analytic minimum UVLO restart delay; 0 = WP1 reference), ramp 1.9 ms (LM70880 tSS min 1.9 ms),
* 2.72 uH + 15.4 mOhm to RAW; RAW bank 165 uF / 12.5 mOhm / 2 nH. Loads 7.5 A ramp in after DRIVE settles.
.include ../../../pdu-behavioral.lib
.include ../../../pdu-inductor-ng.lib
.include ../../2026-10-25-o1-ovp/pdu-o1ovp-behavioral.lib
.include ../../2026-10-25-o1-ovp/pdu-efuse-block-o1ovp.inc
.include ../pdu-o1ovp-block-uvlo.inc
.param TDON=1.68u TDOV=5.55u IBST=100u IPU=1.69 IPD=2 VTH_P=1.5 CGS_P=5n NPAR=2 RON_P=1.8m VBSTR=9 VCPOFF=11.6 CBIAS=0.5 LFACTOR=1 VOL=0 RT_P=2050 RB_P=1150 CMP_VTRIP=1.5m CMP_VREL=-1.5m CMP_IB=1u TDOFF=0.3625u VREF_P=4.096 CRAW=165u ESR=12.5m V5_P=5.0
Vaux VIN 0 26
Vsource DRIVE 0 PWL(0 0 0.07782371 0 0.07972371 11.1605)
Lfault DRIVE LF 2.72u
RfaultDCR LF RAW 0.0154
Craw RAW_C 0 {CRAW}
Resr RAW RAW_E {ESR}
Lesl RAW_E RAW_C 2n
Bload1 O1_11V 0 I=(3)*min(max((time-0.08272371)/1m,0),1)*min(max(V(O1_11V)/5,0),1)
Bload2 S2E_11V 0 I=(1.5)*min(max((time-0.08272371)/1m,0),1)*min(max(V(S2E_11V)/5,0),1)
Bextra VOUT 0 I=(3)*min(max((time-0.08272371)/1m,0),1)*min(max(V(VOUT)/5,0),1)
Rbleed VOUT 0 100k
.tran 100n 0.1097237 0 100n uic
.options reltol=0.0001 abstol=1n method=gear
.options plotwinsize=0
.meas tran FET_ON1 WHEN V(M_VGS)=6 RISE=1
.meas tran FET_OFF1 WHEN V(M_VGS)=6 FALL=1
.meas tran INP_MIN_AFTER_ON MIN V(INP_OVP) FROM=0.06 TO=0.1097237
.meas tran RAW_MAX MAX V(RAW) FROM=0 TO=0.1097237
.meas tran O1_GLOBAL_PEAK MAX V(O1_11V) FROM=0 TO=0.1097237
.meas tran BUS_STARTUP_MAX MAX V(VOUT) FROM=0 TO=0.08972371
.meas tran RUN_BUS_MAX MAX V(VOUT) FROM=0.0897237 TO=0.109724
.meas tran RUN_O1_MAX MAX V(O1_11V) FROM=0.0897237 TO=0.109724
.meas tran RUN_RAW_AVG AVG V(RAW) FROM=0.0897237 TO=0.109724
.meas tran RUN_O1_AVG AVG V(O1_11V) FROM=0.0897237 TO=0.109724
.meas tran RUN_VIN_MIN MIN V(VIN) FROM=0.0897237 TO=0.109724
.meas tran RUN_EN_MIN MIN V(EN_BUCK) FROM=0.0897237 TO=0.109724
.meas tran RUN_VGS_MIN MIN V(M_VGS) FROM=0.0897237 TO=0.109724
.meas tran RUN_INP_MIN MIN V(INP_OVP) FROM=0.0897237 TO=0.109724
.save V(RAW) V(VOUT) V(O1_11V) V(S2E_11V) V(INP_OVP) V(M_VGS) V(DRIVE) V(V5_OVP)
.end
