* WP2 2026-10-25-uvlo proposal bench (BEHAVIORAL/IDEAL models; NOT vendor silicon). Generated by gen_uvlo.py.
* ngspice-44.2 only (run with -D ngbehavior=ltpsa). LTspice: bulut ortaminda calistirilmadi.
* motorboat hold: start at 21 V, ramp 10 V/s to E*-0.05 = 19.2805 V and hold 0.45 s; R 0.25; mbmin/tmin
.include ../../../pdu-behavioral.lib
.include ../../../pdu-inductor-ng.lib
.include ../../2026-10-25-o1-ovp/pdu-o1ovp-behavioral.lib
.include ../pdu-uvlo-behavioral.lib
.include ../pdu-circuit-uvlo.inc
.include ../pdu-o1ovp-block-uvlo.inc
.include ../pdu-uvlo-block.inc
.param TDON=1.68u TDOV=5.55u IBST=345u IPU=1.69 IPD=2 VTH_P=1.5 CGS_P=5n NPAR=2 RON_P=1.8m VBSTR=9 VCPOFF=11.6 CBIAS=0.5 LFACTOR=1 VOL=0 RT_P=2050 RB_P=1150 CMP_VTRIP=1.5m CMP_VREL=-1.5m CMP_IB=1u TDOFF=0.3625u RTU=39043.2 RBU=8905.48 RXU=91263.6 RR1U=10040 RR2U=46214.4 VREF_P=4.083862 VIOA=-0.006911229 HINTA=0 IS_U=-7e-09 IM_U=-5e-09 RON_U=4.9 RTT=10956 RHB=1030000 RK1=10056.54 RK2=40039.2 CTT=5.08725e-06 V5_P=4.9 VOHD=0 ILKD=3e-05 VIOB=-0.007652234 HINTB=0 RK1A=10542 RK4=216300 RON_K=4.9 RST=99600 CST=1.417575e-07 RSA=1648000 RSB=970000 RDSC=97 VTHS=0.87 VENR=1.0 VENF=0.9 TSS=2.8m RUV1_P=180000 RUV2_P=10000
* LiPo + harness: R_total 0.25 ohm = R0 0.0896 + R1 0.0448 (polarisation, tau 20 ms accelerated) + Rcab 0.0896 + board 0.026 (R_F1+Q1); Lcab 1u
Vemf EMFC 0 PWL(0 0 100u 21 0.167038 21 0.338985 19.280532)
Xbat EMFC VBAT 0 UVLO_LIPO R0=0.0896 R1=0.0448 TAU=20m LCAB=1u RCAB=0.0896
Bload1 O1_11V 0 I=(3)*min(max(V(O1_11V)/5,0),1)
Bload2 S2E_11V 0 I=(1.5)*min(max(V(S2E_11V)/5,0),1)
Bextra VOUT 0 I=(3)*min(max(V(VOUT)/5,0),1)
Rbleed VOUT 0 100k
* conversion loss: P_IN = P_RAW/0.88 (ASSUMPTION eta 0.88 @ 7.5 A); housekeeping 0.1 W (ASSUMPTION) as Rhk
Bloss VIN 0 I=0.13636*max(V(RAW)*(V(ISNS1,RAW)+V(ISNS2,RAW))/0.0075,0)/max(V(VIN),1)
Rhk VIN 0 4k
.tran 100n 0.788985 0 1u uic
.options reltol=0.0001 abstol=1n method=gear
.options plotwinsize=0
.meas tran EN_R1 WHEN V(EN_BUCK)=1.0 RISE=1
.meas tran EN_F1 WHEN V(EN_BUCK)=1.0 FALL=1
.meas tran EN_R2 WHEN V(EN_BUCK)=1.0 RISE=2
.meas tran EN_F2 WHEN V(EN_BUCK)=1.0 FALL=2
.meas tran EN_R3 WHEN V(EN_BUCK)=1.0 RISE=3
.meas tran EN_F3 WHEN V(EN_BUCK)=1.0 FALL=3
.meas tran EN_R4 WHEN V(EN_BUCK)=1.0 RISE=4
.meas tran EN_F4 WHEN V(EN_BUCK)=1.0 FALL=4
.meas tran OUTA_R1 WHEN V(OUTA_UV)=2.5 RISE=1
.meas tran OUTA_F1 WHEN V(OUTA_UV)=2.5 FALL=1
.meas tran OUTA_R2 WHEN V(OUTA_UV)=2.5 RISE=2
.meas tran OUTA_R3 WHEN V(OUTA_UV)=2.5 RISE=3
.meas tran OUTA_RLAST WHEN V(OUTA_UV)=2.5 RISE=LAST
.meas tran OUTA_F2 WHEN V(OUTA_UV)=2.5 FALL=2
.meas tran OUTA_R4 WHEN V(OUTA_UV)=2.5 RISE=4
.meas tran OUTA_R5 WHEN V(OUTA_UV)=2.5 RISE=5
.meas tran EN_RLAST WHEN V(EN_BUCK)=1.0 RISE=LAST
.meas tran FET_ON1 WHEN V(M_VGS)=6 RISE=1
.meas tran FET_ON2 WHEN V(M_VGS)=6 RISE=2
.meas tran FET_OFF1 WHEN V(M_VGS)=6 FALL=1
.meas tran O1_GLOBAL_PEAK MAX V(O1_11V) FROM=0 TO=0.788985
.meas tran BUS_GLOBAL_MAX MAX V(VOUT) FROM=0 TO=0.788985
.meas tran RAW_GLOBAL_MAX MAX V(RAW) FROM=0 TO=0.788985
.meas tran VIN_GLOBAL_MAX MAX V(VIN) FROM=0 TO=0.788985
.meas tran S_UV_MAX MAX V(S_UV) FROM=0 TO=0.788985
.meas tran SWD_MINUS_V5_MAX MAX V(M_SWDV5) FROM=0 TO=0.788985
.meas tran S_MINUS_V5_MAX MAX V(M_SV5) FROM=0 TO=0.788985
Bm1 M_SWDV5 0 V=V(SWD_UV)-V(V5_OVP)
Bm2 M_SV5 0 V=V(S_UV)-V(V5_OVP)
.meas tran PRE_BUS_MAX MAX V(VOUT) FROM=0.137038 TO=0.167038
.meas tran PRE_O1_MAX MAX V(O1_11V) FROM=0.137038 TO=0.167038
.meas tran PRE_RAW_AVG AVG V(RAW) FROM=0.137038 TO=0.167038
.meas tran PRE_O1_AVG AVG V(O1_11V) FROM=0.137038 TO=0.167038
.meas tran PRE_VIN_MIN MIN V(VIN) FROM=0.137038 TO=0.167038
.meas tran PRE_EN_MIN MIN V(EN_BUCK) FROM=0.137038 TO=0.167038
.meas tran PRE_VGS_MIN MIN V(M_VGS) FROM=0.137038 TO=0.167038
.meas tran PRE_INP_MIN MIN V(INP_OVP) FROM=0.137038 TO=0.167038
.meas tran VIN_MIN_HOLD MIN V(VIN) FROM=0.338985 TO=0.788985
.meas tran VIN_AT_SHUTDOWN FIND V(VIN) WHEN V(EN_BUCK)=1.0 FALL=1
.save V(VIN) V(VBAT) V(EN_BUCK) V(S_UV) V(REFD_UV) V(OUTA_UV) V(T_UV) V(KTH_UV) V(OUTB_UV) V(SWD_UV) V(V5_OVP) V(VREF_OVP) V(RAW) V(VOUT) V(O1_11V) V(S2E_11V) V(INP_OVP) V(M_VGS)
.end
