* WP2 2026-10-25-uvlo proposal bench (BEHAVIORAL/IDEAL models; NOT vendor silicon). Generated by gen_uvlo.py.
* ngspice-44.2 only (run with -D ngbehavior=ltpsa). LTspice: bulut ortaminda calistirilmadi.
* RDSC 180 ohm exploration; brown-out dip0v-300us: 22.2 V -> 0.0 V for 0.3 ms (edges min(20 us, dip/4)); load x1.0; mbmin/tmin/OVP wclo/IBST 100u
.include ../../../pdu-behavioral.lib
.include ../../../pdu-inductor-ng.lib
.include ../../2026-10-25-o1-ovp/pdu-o1ovp-behavioral.lib
.include ../pdu-uvlo-behavioral.lib
.include ../pdu-circuit-uvlo.inc
.include ../pdu-o1ovp-block-uvlo.inc
.include ../pdu-uvlo-block.inc
.param TDON=1.68u TDOV=5.55u IBST=100u IPU=1.69 IPD=2 VTH_P=1.5 CGS_P=5n NPAR=2 RON_P=1.8m VBSTR=9 VCPOFF=11.6 CBIAS=0.5 LFACTOR=1 VOL=0 RT_P=2045.9 RB_P=1152.3 CMP_VTRIP=-9.1m CMP_VREL=-14.1m CMP_IB=-5u TDOFF=1.0545u RTU=39043.2 RBU=8905.48 RXU=91263.6 RR1U=10040 RR2U=46214.4 VREF_P=4.083862 VIOA=-0.006911229 HINTA=0 IS_U=-7e-09 IM_U=-5e-09 RON_U=4.9 RTT=10956 RHB=1030000 RK1=10056.54 RK2=40039.2 CTT=5.08725e-06 V5_P=4.9 VOHD=0 ILKD=3e-05 VIOB=-0.007652234 HINTB=0 RK1A=10542 RK4=216300 RON_K=4.9 RST=99600 CST=1.417575e-07 RSA=1648000 RSB=970000 RDSC=174.6 VTHS=0.87 VENR=1.0 VENF=0.9 TSS=2.8m RUV1_P=180000 RUV2_P=10000
* LiPo + harness: R_total 0.25 ohm = R0 0.0896 + R1 0.0448 (polarisation, tau 20 ms accelerated) + Rcab 0.0896 + board 0.026 (R_F1+Q1); Lcab 1u
Vemf EMFC 0 PWL(0 0 100u 22.2 0.167038267 22.2 0.167058267 0.0 0.167338267 0.0 0.167358267 22.2)
Xbat EMFC VBAT 0 UVLO_LIPO R0=0.0896 R1=0.0448 TAU=20m LCAB=1u RCAB=0.0896
Bload1 O1_11V 0 I=(3)*min(max(V(O1_11V)/5,0),1)
Bload2 S2E_11V 0 I=(1.5)*min(max(V(S2E_11V)/5,0),1)
Bextra VOUT 0 I=(3)*min(max(V(VOUT)/5,0),1)
Rbleed VOUT 0 100k
* conversion loss: P_IN = P_RAW/0.88 (ASSUMPTION eta 0.88 @ 7.5 A); housekeeping 0.1 W (ASSUMPTION) as Rhk
Bloss VIN 0 I=0.13636*max(V(RAW)*(V(ISNS1,RAW)+V(ISNS2,RAW))/0.0075,0)/max(V(VIN),1)
Rhk VIN 0 4k
.tran 100n 0.369377 0 1u uic
.options reltol=0.0001 abstol=1n method=gear
.options plotwinsize=0
.meas tran EN_R1 WHEN V(EN_BUCK)=1.0 RISE=1
.meas tran EN_F1 WHEN V(EN_BUCK)=1.0 FALL=1
.meas tran EN_R2 WHEN V(EN_BUCK)=1.0 RISE=2
.meas tran EN_F2 WHEN V(EN_BUCK)=1.0 FALL=2
.meas tran EN_R3 WHEN V(EN_BUCK)=1.0 RISE=3
.meas tran EN_F3 WHEN V(EN_BUCK)=1.0 FALL=3
.meas tran EN_R4 WHEN V(EN_BUCK)=1.0 RISE=4
.meas tran EN_F4 WHEN V(EN_BUCK)=1.0 FALL=4
.meas tran OUTA_R1 WHEN V(OUTA_UV)=2.5 RISE=1
.meas tran OUTA_F1 WHEN V(OUTA_UV)=2.5 FALL=1
.meas tran OUTA_R2 WHEN V(OUTA_UV)=2.5 RISE=2
.meas tran OUTA_R3 WHEN V(OUTA_UV)=2.5 RISE=3
.meas tran OUTA_RLAST WHEN V(OUTA_UV)=2.5 RISE=LAST
.meas tran OUTA_F2 WHEN V(OUTA_UV)=2.5 FALL=2
.meas tran OUTA_R4 WHEN V(OUTA_UV)=2.5 RISE=4
.meas tran OUTA_R5 WHEN V(OUTA_UV)=2.5 RISE=5
.meas tran EN_RLAST WHEN V(EN_BUCK)=1.0 RISE=LAST
.meas tran FET_ON1 WHEN V(M_VGS)=6 RISE=1
.meas tran FET_ON2 WHEN V(M_VGS)=6 RISE=2
.meas tran FET_OFF1 WHEN V(M_VGS)=6 FALL=1
.meas tran O1_GLOBAL_PEAK MAX V(O1_11V) FROM=0 TO=0.369377
.meas tran BUS_GLOBAL_MAX MAX V(VOUT) FROM=0 TO=0.369377
.meas tran RAW_GLOBAL_MAX MAX V(RAW) FROM=0 TO=0.369377
.meas tran VIN_GLOBAL_MAX MAX V(VIN) FROM=0 TO=0.369377
.meas tran S_UV_MAX MAX V(S_UV) FROM=0 TO=0.369377
.meas tran SWD_MINUS_V5_MAX MAX V(M_SWDV5) FROM=0 TO=0.369377
.meas tran S_MINUS_V5_MAX MAX V(M_SV5) FROM=0 TO=0.369377
Bm1 M_SWDV5 0 V=V(SWD_UV)-V(V5_OVP)
Bm2 M_SV5 0 V=V(S_UV)-V(V5_OVP)
.meas tran PRE_BUS_MAX MAX V(VOUT) FROM=0.137038 TO=0.167038
.meas tran PRE_O1_MAX MAX V(O1_11V) FROM=0.137038 TO=0.167038
.meas tran PRE_RAW_AVG AVG V(RAW) FROM=0.137038 TO=0.167038
.meas tran PRE_O1_AVG AVG V(O1_11V) FROM=0.137038 TO=0.167038
.meas tran PRE_VIN_MIN MIN V(VIN) FROM=0.137038 TO=0.167038
.meas tran PRE_EN_MIN MIN V(EN_BUCK) FROM=0.137038 TO=0.167038
.meas tran PRE_VGS_MIN MIN V(M_VGS) FROM=0.137038 TO=0.167038
.meas tran PRE_INP_MIN MIN V(INP_OVP) FROM=0.137038 TO=0.167038
.meas tran POST_BUS_MAX MAX V(VOUT) FROM=0.319377 TO=0.369377
.meas tran POST_O1_MAX MAX V(O1_11V) FROM=0.319377 TO=0.369377
.meas tran POST_RAW_AVG AVG V(RAW) FROM=0.319377 TO=0.369377
.meas tran POST_O1_AVG AVG V(O1_11V) FROM=0.319377 TO=0.369377
.meas tran POST_VIN_MIN MIN V(VIN) FROM=0.319377 TO=0.369377
.meas tran POST_EN_MIN MIN V(EN_BUCK) FROM=0.319377 TO=0.369377
.meas tran POST_VGS_MIN MIN V(M_VGS) FROM=0.319377 TO=0.369377
.meas tran POST_INP_MIN MIN V(INP_OVP) FROM=0.319377 TO=0.369377
.meas tran O1_DIP_MAX MAX V(O1_11V) FROM=0.167038 TO=0.369377
.meas tran BUS_RESTART_MAX MAX V(VOUT) FROM=0.167338 TO=0.319377
.meas tran RAW_RESTART_MAX MAX V(RAW) FROM=0.167338 TO=0.319377
.meas tran INP_RESTART_MIN MIN V(INP_OVP) FROM=0.167338 TO=0.319377
.meas tran RAW_AT_DIP_END FIND V(RAW) AT=0.167338
.meas tran T_AT_DIP_END FIND V(T_UV) AT=0.167338
Brdb M_RDB 0 V=min(max((V(VOUT)-11.1605)/1e-4,0),1)
Brdo M_RDO 0 V=min(max((V(O1_11V)-11.1605)/1e-4,0),1)
.meas tran RD_PEAK MAX V(VOUT) FROM=0.167038 TO=0.369377
.meas tran RD_T_ABOVE INTEG V(M_RDB) FROM=0.167038 TO=0.369377
.meas tran RD_ABOVE_FIRST WHEN V(VOUT)=11.1605 RISE=1 FROM=0.167038
.meas tran RD_ABOVE_LAST WHEN V(VOUT)=11.1605 FALL=LAST FROM=0.167038
.meas tran RD_PEAK_O1 MAX V(O1_11V) FROM=0.167038 TO=0.369377
.meas tran RD_T_ABOVE_O1 INTEG V(M_RDO) FROM=0.167038 TO=0.369377
.meas tran VT_AT_OUTA_R1 FIND V(T_UV) WHEN V(OUTA_UV)=2.5 RISE=1
.meas tran VT_AT_OUTA_R2 FIND V(T_UV) WHEN V(OUTA_UV)=2.5 RISE=2
.meas tran VT_AT_OUTA_R3 FIND V(T_UV) WHEN V(OUTA_UV)=2.5 RISE=3
.meas tran VT_AT_OUTA_RLAST FIND V(T_UV) WHEN V(OUTA_UV)=2.5 RISE=LAST
.meas tran VT_AT_EN_R2 FIND V(T_UV) WHEN V(EN_BUCK)=1.0 RISE=2
.meas tran VT_AT_EN_R3 FIND V(T_UV) WHEN V(EN_BUCK)=1.0 RISE=3
.meas tran EN_LAG_F1 TRIG V(OUTA_UV) VAL=2.5 FALL=1 TARG V(EN_BUCK) VAL=1.0 FALL=1
.meas tran EN_LAG_F2 TRIG V(OUTA_UV) VAL=2.5 FALL=2 TARG V(EN_BUCK) VAL=1.0 FALL=2
.meas tran VGS_AT_EN_R1 FIND V(M_VGS) WHEN V(EN_BUCK)=1.0 RISE=1
.meas tran VGS_AT_EN_R2 FIND V(M_VGS) WHEN V(EN_BUCK)=1.0 RISE=2
.meas tran VGS_AT_EN_R3 FIND V(M_VGS) WHEN V(EN_BUCK)=1.0 RISE=3
.meas tran VGS_AT_EN_R4 FIND V(M_VGS) WHEN V(EN_BUCK)=1.0 RISE=4
.meas tran VGS_AT_EN_RLAST FIND V(M_VGS) WHEN V(EN_BUCK)=1.0 RISE=LAST
.meas tran VGS_MIN_AFTER_T0 MIN V(M_VGS) FROM=0.167038 TO=0.369377
.meas tran EN_MIN_AFTER_T0 MIN V(EN_BUCK) FROM=0.167038 TO=0.369377
.meas tran V5_MIN_DIP MIN V(V5_OVP) FROM=0.167038 TO=0.177338
.meas tran VT_MIN_POST MIN V(T_UV) FROM=0.167338 TO=0.369377
.meas tran OUTAD_MIN MIN V(OUTA_D) FROM=0.167038 TO=0.369377
Bmrel M_REL 0 V=V(SEL24_UV)-{VTHS}
.meas tran T_REL WHEN V(M_REL)=0 RISE=LAST
.meas tran VT_AT_REL FIND V(T_UV) WHEN V(M_REL)=0 RISE=LAST
.save V(VIN) V(VBAT) V(EN_BUCK) V(S_UV) V(REFD_UV) V(OUTA_UV) V(T_UV) V(KTH_UV) V(OUTB_UV) V(SWD_UV) V(V5_OVP) V(VREF_OVP) V(RAW) V(VOUT) V(O1_11V) V(S2E_11V) V(INP_OVP) V(M_VGS)
.end
