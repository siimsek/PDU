* G1 shared bus OVP: common disconnect ahead of both TPS25982 IN groups.
* Behavioral component/timing screen only; no physical result.
.param VTRIP=11.6231688336 TDELAY=3.254e-07 CLATCH=1n CBUK=92.6514u
Vshort VIN 0 PWL(0 11.2096431711 999u 11.2096431711 1m 26 2m 26)
Rcoil VIN LNODE 0.03245
Lfault LNODE VRAW 5.44u IC=6.46049833887
CBUS VRAW 0 {CBUK} IC=11
Rbleed VRAW 0 1k
VSW_SENSE VRAW VRAW_SW 0
Sbus VRAW_SW VSAFE CTRL_BUS 0 OVPSW
Clatch_BUS CTRL_BUS 0 {CLATCH} IC=1
Rlatch_BUS CTRL_BUS 0 1T
Btrip_BUS CTRL_BUS 0 I=if(V(VRAW)>VTRIP,CLATCH*(1-0.45)/TDELAY,0)
.model OVPSW SW(Ron=5.6m Roff=1T Vt=0.5 Vh=0.05)
* Exported-netlist input caps: two 100 nF parts; BOM/derating not established.
V_CEFIN1_SENSE VSAFE CEFIN1_NODE 0
CEFIN1 CEFIN1_NODE 0 100n IC=11
V_CEFIN2_SENSE VSAFE CEFIN2_NODE 0
CEFIN2 CEFIN2_NODE 0 100n IC=11
* Existing branch eFuse behavioral switches; not TPS25982 silicon.
V_EFUSE_O1_SENSE VSAFE VSAFE_O1 0
Sefuse_O1 VSAFE_O1 O1 CTRL_EF1 0 EFUSESW
Clatch_EF1 CTRL_EF1 0 10n IC=1
Rlatch_EF1 CTRL_EF1 0 1T
Btrip_EF1 CTRL_EF1 0 I=if(V(VSAFE)>16.32,1m,0)
V_EFUSE_S2E_SENSE VSAFE VSAFE_S2E 0
Sefuse_S2E VSAFE_S2E S2E CTRL_EF2 0 EFUSESW
Clatch_EF2 CTRL_EF2 0 10n IC=1
Rlatch_EF2 CTRL_EF2 0 1T
Btrip_EF2 CTRL_EF2 0 I=if(V(VSAFE)>16.32,1m,0)
.model EFUSESW SW(Ron=10m Roff=1T Vt=0.5 Vh=0.05)
V_CEFOUT1_SENSE O1 CEFOUT1_NODE 0
CEFOUT1 CEFOUT1_NODE 0 10u IC=11
V_CEFOUT2_SENSE S2E CEFOUT2_NODE 0
CEFOUT2 CEFOUT2_NODE 0 10u IC=11
* VARSAYIM: O1 branch at configured nominal ILIM; actual port current unmeasured.
V_LOAD_O1_SENSE O1 O1_LOAD 0
BLOAD_O1 O1_LOAD 0 I=4.96049833887*min(max(V(O1)/11,0),1)
* DATASHEET: S2E steady/start-up max at 12 V, held constant as sensitivity only.
V_LOAD_S2E_SENSE S2E S2E_LOAD 0
BLOAD_S2E S2E_LOAD 0 I=1.5*min(max(V(S2E)/11,0),1)
.ic V(VRAW)=11 V(VSAFE)=11 V(O1)=10.9 V(S2E)=10.9
.tran 10n 2m 0 20n uic
.options reltol=0.0001 abstol=1n method=gear
.meas tran RAW_PEAK MAX V(VRAW) FROM=1m TO=2m
.meas tran U3_IN_PEAK MAX V(VSAFE) FROM=1m TO=2m
.meas tran U4_IN_PEAK MAX V(VSAFE) FROM=1m TO=2m
.meas tran O1_PEAK MAX V(O1) FROM=1m TO=2m
.meas tran S2E_PEAK MAX V(S2E) FROM=1m TO=2m
.meas tran PHASE_CURRENT_PEAK MAX I(Lfault) FROM=1m TO=2m
.meas tran COMMON_SWITCH_BRANCH_I_PEAK MAX I(VSW_SENSE) FROM=1m TO=1.02m
.meas tran COMMON_SWITCH_I_AT_TRIP FIND I(VSW_SENSE) WHEN V(VRAW)=VTRIP RISE=1
.meas tran COMMON_SWITCH_I_AT_OPEN FIND I(VSW_SENSE) WHEN V(CTRL_BUS)=0.45 FALL=1
.meas tran O1_MIN MIN V(O1) FROM=1m TO=2m
.meas tran S2E_MIN MIN V(S2E) FROM=1m TO=2m
.meas tran BUS_TRIP WHEN V(VRAW)=VTRIP RISE=1
.meas tran BUS_OPEN WHEN V(CTRL_BUS)=0.45 FALL=1
.meas tran BUS_T_OFF TRIG V(VRAW) VAL=VTRIP RISE=1 TARG V(CTRL_BUS) VAL=0.45 FALL=1
BINT_CAND_U3_GT24 0 T_CAND_U3_GT24 I=if(V(VSAFE)>24.0,1u,0)
CT_CAND_U3_GT24 T_CAND_U3_GT24 0 1u IC=0
RT_CAND_U3_GT24 T_CAND_U3_GT24 0 1T
.meas tran CAND_U3_GT24_DURATION_S FIND V(T_CAND_U3_GT24) AT=2m
BINT_CAND_U4_GT24 0 T_CAND_U4_GT24 I=if(V(VSAFE)>24.0,1u,0)
CT_CAND_U4_GT24 T_CAND_U4_GT24 0 1u IC=0
RT_CAND_U4_GT24 T_CAND_U4_GT24 0 1T
.meas tran CAND_U4_GT24_DURATION_S FIND V(T_CAND_U4_GT24) AT=2m
BINT_CAND_U3_GT30 0 T_CAND_U3_GT30 I=if(V(VSAFE)>30.0,1u,0)
CT_CAND_U3_GT30 T_CAND_U3_GT30 0 1u IC=0
RT_CAND_U3_GT30 T_CAND_U3_GT30 0 1T
.meas tran CAND_U3_GT30_DURATION_S FIND V(T_CAND_U3_GT30) AT=2m
BINT_CAND_U4_GT30 0 T_CAND_U4_GT30 I=if(V(VSAFE)>30.0,1u,0)
CT_CAND_U4_GT30 T_CAND_U4_GT30 0 1u IC=0
RT_CAND_U4_GT30 T_CAND_U4_GT30 0 1T
.meas tran CAND_U4_GT30_DURATION_S FIND V(T_CAND_U4_GT30) AT=2m
BINT_Q_SW 0 T_Q_SW I=if(time>1m,I(VSW_SENSE),0)
CQ_SW T_Q_SW 0 1 IC=0
RQ_SW T_Q_SW 0 1T
.meas tran Q_SW_C FIND V(T_Q_SW) AT=2m
BINT_Q_IN1 0 T_Q_IN1 I=if(time>1m,I(V_CEFIN1_SENSE),0)
CQ_IN1 T_Q_IN1 0 1 IC=0
RQ_IN1 T_Q_IN1 0 1T
.meas tran Q_IN1_C FIND V(T_Q_IN1) AT=2m
BINT_Q_IN2 0 T_Q_IN2 I=if(time>1m,I(V_CEFIN2_SENSE),0)
CQ_IN2 T_Q_IN2 0 1 IC=0
RQ_IN2 T_Q_IN2 0 1T
.meas tran Q_IN2_C FIND V(T_Q_IN2) AT=2m
BINT_Q_EF1 0 T_Q_EF1 I=if(time>1m,I(V_EFUSE_O1_SENSE),0)
CQ_EF1 T_Q_EF1 0 1 IC=0
RQ_EF1 T_Q_EF1 0 1T
.meas tran Q_EF1_C FIND V(T_Q_EF1) AT=2m
BINT_Q_EF2 0 T_Q_EF2 I=if(time>1m,I(V_EFUSE_S2E_SENSE),0)
CQ_EF2 T_Q_EF2 0 1 IC=0
RQ_EF2 T_Q_EF2 0 1T
.meas tran Q_EF2_C FIND V(T_Q_EF2) AT=2m
BINT_Q_OUT1 0 T_Q_OUT1 I=if(time>1m,I(V_CEFOUT1_SENSE),0)
CQ_OUT1 T_Q_OUT1 0 1 IC=0
RQ_OUT1 T_Q_OUT1 0 1T
.meas tran Q_OUT1_C FIND V(T_Q_OUT1) AT=2m
BINT_Q_OUT2 0 T_Q_OUT2 I=if(time>1m,I(V_CEFOUT2_SENSE),0)
CQ_OUT2 T_Q_OUT2 0 1 IC=0
RQ_OUT2 T_Q_OUT2 0 1T
.meas tran Q_OUT2_C FIND V(T_Q_OUT2) AT=2m
BINT_Q_LOAD1 0 T_Q_LOAD1 I=if(time>1m,I(V_LOAD_O1_SENSE),0)
CQ_LOAD1 T_Q_LOAD1 0 1 IC=0
RQ_LOAD1 T_Q_LOAD1 0 1T
.meas tran Q_LOAD1_C FIND V(T_Q_LOAD1) AT=2m
BINT_Q_LOAD2 0 T_Q_LOAD2 I=if(time>1m,I(V_LOAD_S2E_SENSE),0)
CQ_LOAD2 T_Q_LOAD2 0 1 IC=0
RQ_LOAD2 T_Q_LOAD2 0 1T
.meas tran Q_LOAD2_C FIND V(T_Q_LOAD2) AT=2m
.meas tran I_IN1_MAX MAX I(V_CEFIN1_SENSE) FROM=1m TO=1.02m
.meas tran I_IN1_MIN MIN I(V_CEFIN1_SENSE) FROM=1m TO=1.02m
.meas tran I_IN2_MAX MAX I(V_CEFIN2_SENSE) FROM=1m TO=1.02m
.meas tran I_IN2_MIN MIN I(V_CEFIN2_SENSE) FROM=1m TO=1.02m
.meas tran I_OUT1_MAX MAX I(V_CEFOUT1_SENSE) FROM=1m TO=1.02m
.meas tran I_OUT1_MIN MIN I(V_CEFOUT1_SENSE) FROM=1m TO=1.02m
.meas tran I_OUT2_MAX MAX I(V_CEFOUT2_SENSE) FROM=1m TO=1.02m
.meas tran I_OUT2_MIN MIN I(V_CEFOUT2_SENSE) FROM=1m TO=1.02m
.end
