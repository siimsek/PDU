* Family-2 buck high-side short plus O1 branch OVP candidate timing screen.
* Shared VOUT still feeds S2E. eFuse circuit-breaker current dynamics are not modeled.
* Comparator/latch/driver delay is folded into TDELAY; FETs are Ron/Roff switches.
.param VTRIP=11.6229791496 CBUK=92.6514u COUT=10u
.param TDELAY=325.4n CLATCH=1n VSWITCH=0.5
Vshort VIN 0 PWL(0 11 999u 11 1m 26 2m 26)
Rcoil VIN LNODE 0.03245
Lfault LNODE VOUT 5.44u IC=0
CBUS VOUT 0 {CBUK} IC=11
Rbleed VOUT 0 1k
Sefuse VOUT PRE CTRL_EF 0 EFUSESW
Clatch_EF CTRL_EF 0 10n IC=1
Rlatch_EF CTRL_EF 0 1T
Btrip_EF CTRL_EF 0 I=if(V(VOUT)>16.32,1m,0)
.model EFUSESW SW(Ron=10m Roff=1T Vt=0.5 Vh=0.05)
VSW_SENSE PRE PRE_OVP 0
Sdisconnect PRE_OVP O1 CTRL_OVP 0 OVPSW
Clatch_OVP CTRL_OVP 0 {CLATCH} IC=1
Rlatch_OVP CTRL_OVP 0 1T
Btrip_OVP CTRL_OVP 0 I=if(V(O1)>VTRIP,CLATCH*VSWITCH/TDELAY,0)
.model OVPSW SW(Ron=5.6m Roff=1T Vt=0.5 Vh=0.05)
CEFOUT O1 0 {COUT} IC=10.9
Rload1 O1 0 1.57
Sefuse_S2E VOUT S2E CTRL_S2E 0 EFUSESW
Clatch_S2E CTRL_S2E 0 10n IC=1
Rlatch_S2E CTRL_S2E 0 1T
Btrip_S2E CTRL_S2E 0 I=if(V(VOUT)>16.32,1m,0)
CEFOUT_S2E S2E 0 10u IC=10.9
Rload_S2E S2E 0 2.2
.ic V(VOUT)=11 V(O1)=10.9 V(S2E)=10.9
.tran 10n 2m 0 20n uic
.options reltol=0.0001 abstol=1n method=gear
.meas tran BUS_PEAK MAX V(VOUT) FROM=1m TO=2m
.meas tran O1_PEAK MAX V(O1) FROM=1m TO=2m
.meas tran S2E_PEAK MAX V(S2E) FROM=1m TO=2m
.meas tran PHASE_CURRENT MAX I(Lfault) FROM=1m TO=2m
.meas tran OVP_I_PEAK MAX I(VSW_SENSE) FROM=1m TO=1.2m
.meas tran OVP_TRIP WHEN V(O1)=VTRIP RISE=1
.meas tran CTRL_OPEN WHEN V(CTRL_OVP)=0.45 FALL=1
.meas tran OVP_TOFF TRIG V(O1) VAL=VTRIP RISE=1 TARG V(CTRL_OVP) VAL=0.45 FALL=1
.end
