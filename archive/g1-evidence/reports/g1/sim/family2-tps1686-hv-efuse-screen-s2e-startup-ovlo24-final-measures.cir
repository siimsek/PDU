* TPS1686 high-voltage eFuse concept: input withstand plus port OVLO.
* 3 us is a published minimum tOVP; no maximum is specified, so this is not WC.
.param TOvp=3e-06 CLATCH=1n CBUK=92.6514u
Vshort VIN 0 PWL(0 11.2096431711 999u 11.2096431711 1m 26 2m 26)
Rcoil VIN LNODE 0.03245
Lfault LNODE VRAW 5.44u IC=6.46049833887
CBUS VRAW 0 {CBUK} IC=11
Rbleed VRAW 0 1k
* 80 V rated eFuse candidate sees the raw bus directly.
* OVLO thresholds are ideal nominal screens, not selected divider corners.
Sefuse_O1 VRAW O1 CTRL_O1 0 EFUSESW
Clatch_O1 CTRL_O1 0 {CLATCH} IC=1
Rlatch_O1 CTRL_O1 0 1T
Btrip_O1 CTRL_O1 0 I=if(V(VRAW)>11.3,CLATCH*(1-0.45)/TOvp,0)
Sefuse_S2E VRAW S2E CTRL_S2E 0 EFUSESW
Clatch_S2E CTRL_S2E 0 {CLATCH} IC=1
Rlatch_S2E CTRL_S2E 0 1T
Btrip_S2E CTRL_S2E 0 I=if(V(VRAW)>24,CLATCH*(1-0.45)/TOvp,0)
.model EFUSESW SW(Ron=16m Roff=1T Vt=0.5 Vh=0.05)
CEFOUT1 O1 0 10u IC=11
CEFOUT2 S2E 0 10u IC=11
BLOAD_O1 O1 0 I=4.96049833887*min(max(V(O1)/11,0),1)
BLOAD_S2E S2E 0 I=1.5*min(max(V(S2E)/11,0),1)
.ic V(VRAW)=11 V(O1)=11 V(S2E)=11
.tran 10n 2m 0 20n uic
.options reltol=0.0001 abstol=1n method=gear
.meas tran RAW_PEAK MAX V(VRAW) FROM=1m TO=2m
.meas tran O1_PEAK MAX V(O1) FROM=1m TO=2m
.meas tran S2E_PEAK MAX V(S2E) FROM=1m TO=2m
.meas tran PHASE_CURRENT_PEAK MAX I(Lfault) FROM=1m TO=2m
.meas tran O1_TRIP WHEN V(VRAW)=11.3 RISE=1
.meas tran S2E_TRIP WHEN V(VRAW)=24 RISE=1
BINT_HV_U3_GT24 0 T_HV_U3_GT24 I=if(V(VRAW)>24.0,1u,0)
CT_HV_U3_GT24 T_HV_U3_GT24 0 1u IC=0
RT_HV_U3_GT24 T_HV_U3_GT24 0 1T
.meas tran HV_U3_GT24_DURATION_S FIND V(T_HV_U3_GT24) AT=2m
BINT_HV_U3_GT30 0 T_HV_U3_GT30 I=if(V(VRAW)>30.0,1u,0)
CT_HV_U3_GT30 T_HV_U3_GT30 0 1u IC=0
RT_HV_U3_GT30 T_HV_U3_GT30 0 1T
.meas tran HV_U3_GT30_DURATION_S FIND V(T_HV_U3_GT30) AT=2m
.end
