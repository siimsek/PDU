* eFuse output dV/dt and port hot-plug; model only.
.include pdu-protection.inc
Vbus VOUT 0 PWL(0 0 1m 0 1.001m 11 12m 11)
Bload1 O1_11V 0 I=1*min(max(V(O1_11V)/5,0),1)
Bload2 S2E_11V 0 I=0.5*min(max(V(S2E_11V)/5,0),1)
.tran 100n 12m 0 200n uic
.options reltol=0.0001 abstol=1n method=gear
.meas tran O1_PEAK MAX V(O1_11V) FROM=1m TO=12m
.meas tran O1_FINAL AVG V(O1_11V) FROM=10m TO=12m
.meas tran S2E_FINAL AVG V(S2E_11V) FROM=10m TO=12m
.end
