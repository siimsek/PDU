* Measure switch-edge timing in preserved Family-1 ideal latch model.
* Model's CTRL falling threshold is Vt-Vh=0.45 V; not a physical switch.
.param VTRIP=11.46 COUT=10u TDELAY=0.5u CLATCH=1n VSWITCH=0.5
Vfault SOURCE 0 PWL(0 11 4.999m 11 5m 16.9 5.2m 16.9 5.201m 11 6m 11)
Rsource SOURCE PRE 0.54
VSW_SENSE PRE PRE_SW 0
Sdisconnect PRE_SW O1 CTRL 0 IDEALSW
Clatch CTRL 0 {CLATCH} IC=1
Rlatch CTRL 0 1T
Btrip CTRL 0 I=if(V(O1)>VTRIP,CLATCH*VSWITCH/TDELAY,0)
.model IDEALSW SW(Ron=10m Roff=1T Vt=0.5 Vh=0.05)
CEFOUT O1 0 {COUT}
Rload O1 0 1Meg
.ic V(O1)=11
.tran 10n 6m 0 20n uic
.options reltol=0.0001 abstol=1n method=gear
.meas tran O1_PEAK MAX V(O1) FROM=4.9m TO=5.2m
.meas tran OVP_TRIP WHEN V(O1)=VTRIP RISE=1
.meas tran CTRL_OPEN WHEN V(CTRL)=0.45 FALL=1
.meas tran OVP_TOFF TRIG V(O1) VAL=VTRIP RISE=1 TARG V(CTRL) VAL=0.45 FALL=1
.meas tran OVP_TO_CURRENT_OFF TRIG V(O1) VAL=VTRIP RISE=1 TARG I(VSW_SENSE) VAL=1m FALL=1
.meas tran I_BEFORE_OFF FIND I(VSW_SENSE) AT=5.0005m
.meas tran I_AFTER_OFF FIND I(VSW_SENSE) AT=5.1m
.end
