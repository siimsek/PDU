* R6 TPS259824O differential stress diagnostic, NOT a silicon model.
* 2x100nF input C per eFuse and 2x10uF output C per port are review-fixture values.
* 100ohm common VIN bleed and 100k O1/54.5ohm S2E loads are explicit assumptions.
* CO_OPEN models the common switch/eFuse opening together; CO_MASK keeps an
* ideal bilateral eFuse SW on to expose the prior reverse-feed masking artifact.
* INPUT_LOSS is a separate precharged-output, VIN=0, eFuse-open corner.
* Only OUT-IN >0.3V voltage/duration is measured; no internal current is inferred.
.model EFUSESW SW(Ron=1m Roff=1T Vt=2.5 Vh=0.1)
VRAW_CO_OPEN SRC_CO_OPEN 0 PWL(0 11 999u 11 1m 40.709 12m 40.709)
VBC_CO_OPEN BUSCTRL_CO_OPEN 0 PWL(0 0 999u 0 1m 5 12m 5)
SBUS_CO_OPEN SRC_CO_OPEN VIN_CO_OPEN BUSCTRL_CO_OPEN 0 EFUSESW
CIN_CO_OPEN1 VIN_CO_OPEN 0 200n IC=11
CIN_CO_OPEN2 VIN_CO_OPEN 0 200n IC=11
RIN_CO_OPEN VIN_CO_OPEN 0 100
VEC_CO_OPEN CTRL_CO_OPEN 0 PWL(0 0 999u 0 1m 5 12m 5)
COUT_CO_OPEN_O1a O1_CO_OPEN 0 10u IC=11
COUT_CO_OPEN_O1b O1_CO_OPEN 0 10u IC=11
COUT_CO_OPEN_S2Ea S2E_CO_OPEN 0 10u IC=11
COUT_CO_OPEN_S2Eb S2E_CO_OPEN 0 10u IC=11
RLOAD_CO_OPEN_O1 O1_CO_OPEN 0 100k
RLOAD_CO_OPEN_S2E S2E_CO_OPEN 0 54.5
SEF_CO_OPEN_O1 VIN_CO_OPEN O1_CO_OPEN CTRL_CO_OPEN 0 EFUSESW
SEF_CO_OPEN_S2E VIN_CO_OPEN S2E_CO_OPEN CTRL_CO_OPEN 0 EFUSESW
BDIFF_CO_OPEN_O1 DIFF_CO_OPEN_O1 0 V=V(O1_CO_OPEN,VIN_CO_OPEN)
BDIFF_CO_OPEN_S2E DIFF_CO_OPEN_S2E 0 V=V(S2E_CO_OPEN,VIN_CO_OPEN)
BFLAG_CO_OPEN_O1 FLAG_CO_OPEN_O1 0 V=if(V(DIFF_CO_OPEN_O1)>0.3,1,0)
BFLAG_CO_OPEN_S2E FLAG_CO_OPEN_S2E 0 V=if(V(DIFF_CO_OPEN_S2E)>0.3,1,0)
.meas tran MAX_CO_OPEN_O1 MAX V(DIFF_CO_OPEN_O1) FROM=0 TO=12m
.meas tran DUR_CO_OPEN_O1 INTEG V(FLAG_CO_OPEN_O1) FROM=0 TO=12m
.meas tran MAX_CO_OPEN_S2E MAX V(DIFF_CO_OPEN_S2E) FROM=0 TO=12m
.meas tran DUR_CO_OPEN_S2E INTEG V(FLAG_CO_OPEN_S2E) FROM=0 TO=12m

VRAW_CO_MASK SRC_CO_MASK 0 PWL(0 11 999u 11 1m 40.709 12m 40.709)
VBC_CO_MASK BUSCTRL_CO_MASK 0 PWL(0 0 999u 0 1m 5 12m 5)
SBUS_CO_MASK SRC_CO_MASK VIN_CO_MASK BUSCTRL_CO_MASK 0 EFUSESW
CIN_CO_MASK1 VIN_CO_MASK 0 200n IC=11
CIN_CO_MASK2 VIN_CO_MASK 0 200n IC=11
RIN_CO_MASK VIN_CO_MASK 0 100
VEC_CO_MASK CTRL_CO_MASK 0 5
COUT_CO_MASK_O1a O1_CO_MASK 0 10u IC=11
COUT_CO_MASK_O1b O1_CO_MASK 0 10u IC=11
COUT_CO_MASK_S2Ea S2E_CO_MASK 0 10u IC=11
COUT_CO_MASK_S2Eb S2E_CO_MASK 0 10u IC=11
RLOAD_CO_MASK_O1 O1_CO_MASK 0 100k
RLOAD_CO_MASK_S2E S2E_CO_MASK 0 54.5
SEF_CO_MASK_O1 VIN_CO_MASK O1_CO_MASK CTRL_CO_MASK 0 EFUSESW
SEF_CO_MASK_S2E VIN_CO_MASK S2E_CO_MASK CTRL_CO_MASK 0 EFUSESW
BDIFF_CO_MASK_O1 DIFF_CO_MASK_O1 0 V=V(O1_CO_MASK,VIN_CO_MASK)
BDIFF_CO_MASK_S2E DIFF_CO_MASK_S2E 0 V=V(S2E_CO_MASK,VIN_CO_MASK)
BFLAG_CO_MASK_O1 FLAG_CO_MASK_O1 0 V=if(V(DIFF_CO_MASK_O1)>0.3,1,0)
BFLAG_CO_MASK_S2E FLAG_CO_MASK_S2E 0 V=if(V(DIFF_CO_MASK_S2E)>0.3,1,0)
.meas tran MAX_CO_MASK_O1 MAX V(DIFF_CO_MASK_O1) FROM=0 TO=12m
.meas tran DUR_CO_MASK_O1 INTEG V(FLAG_CO_MASK_O1) FROM=0 TO=12m
.meas tran MAX_CO_MASK_S2E MAX V(DIFF_CO_MASK_S2E) FROM=0 TO=12m
.meas tran DUR_CO_MASK_S2E INTEG V(FLAG_CO_MASK_S2E) FROM=0 TO=12m

VZERO_INPUT_LOSS VIN_INPUT_LOSS 0 0
CIN_INPUT_LOSS1 VIN_INPUT_LOSS 0 200n IC=0
CIN_INPUT_LOSS2 VIN_INPUT_LOSS 0 200n IC=0
VEC_INPUT_LOSS CTRL_INPUT_LOSS 0 5
COUT_INPUT_LOSS_O1a O1_INPUT_LOSS 0 10u IC=11
COUT_INPUT_LOSS_O1b O1_INPUT_LOSS 0 10u IC=11
COUT_INPUT_LOSS_S2Ea S2E_INPUT_LOSS 0 10u IC=11
COUT_INPUT_LOSS_S2Eb S2E_INPUT_LOSS 0 10u IC=11
RLOAD_INPUT_LOSS_O1 O1_INPUT_LOSS 0 100k
RLOAD_INPUT_LOSS_S2E S2E_INPUT_LOSS 0 54.5
SEF_INPUT_LOSS_O1 VIN_INPUT_LOSS O1_INPUT_LOSS CTRL_INPUT_LOSS 0 EFUSESW
SEF_INPUT_LOSS_S2E VIN_INPUT_LOSS S2E_INPUT_LOSS CTRL_INPUT_LOSS 0 EFUSESW
BDIFF_INPUT_LOSS_O1 DIFF_INPUT_LOSS_O1 0 V=V(O1_INPUT_LOSS,VIN_INPUT_LOSS)
BDIFF_INPUT_LOSS_S2E DIFF_INPUT_LOSS_S2E 0 V=V(S2E_INPUT_LOSS,VIN_INPUT_LOSS)
BFLAG_INPUT_LOSS_O1 FLAG_INPUT_LOSS_O1 0 V=if(V(DIFF_INPUT_LOSS_O1)>0.3,1,0)
BFLAG_INPUT_LOSS_S2E FLAG_INPUT_LOSS_S2E 0 V=if(V(DIFF_INPUT_LOSS_S2E)>0.3,1,0)
.meas tran MAX_INPUT_LOSS_O1 MAX V(DIFF_INPUT_LOSS_O1) FROM=0 TO=12m
.meas tran DUR_INPUT_LOSS_O1 INTEG V(FLAG_INPUT_LOSS_O1) FROM=0 TO=12m
.meas tran MAX_INPUT_LOSS_S2E MAX V(DIFF_INPUT_LOSS_S2E) FROM=0 TO=12m
.meas tran DUR_INPUT_LOSS_S2E INTEG V(FLAG_INPUT_LOSS_S2E) FROM=0 TO=12m

.tran 10u 12m 0 10u
.options reltol=0.0001 abstol=1n method=gear
.end
