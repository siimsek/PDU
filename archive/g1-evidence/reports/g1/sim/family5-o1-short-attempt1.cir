* O1 output hard short; behavioral O-variant eFuse.
.include pdu-protection.inc
Vbus VOUT 0 11
Bload1 O1_11V 0 I=1*min(max(V(O1_11V)/5,0),1)
Bload2 S2E_11V 0 I=1*min(max(V(S2E_11V)/5,0),1)
Vfault CTRL 0 PWL(0 0 20m 0 20.001m 1 25m 1 25.001m 0)
Sfault O1_11V 0 CTRL 0 FAULTSW
.model FAULTSW SW(Ron=0.1 Roff=1T Vt=0.5 Vh=0.01)
.tran 100n 35m 0 200n uic
.options reltol=0.0001 abstol=1n method=gear
.meas tran O1_SHORT_AVG AVG V(O1_11V) FROM=21m TO=24m
.meas tran O1_SHORT_PEAK MAX V(O1_11V) FROM=20m TO=25m
.meas tran S2E_HEALTHY AVG V(S2E_11V) FROM=21m TO=24m
.meas tran O1_RESET AVG V(O1_11V) FROM=30m TO=34m
.end
