* Buck high-side short: Lmin/hot-DCR path; idealized eFuse OVP timing, not silicon.
.param VTRIP=16.32 CBUK=92.6514u
Vshort VIN 0 PWL(0 11 999u 11 1m 26 2m 26)
Rcoil VIN LNODE 0.03245
Lfault LNODE VOUT 5.44u IC=0
CBUS VOUT 0 {CBUK} IC=11
Rbleed VOUT 0 1k
Sefuse VOUT O1 CTRL 0 EFUSESW
Clatch CTRL 0 10n IC=1
Rlatch CTRL 0 1T
Btrip CTRL 0 I=if(V(VOUT)>VTRIP,1m,0)
.model EFUSESW SW(Ron=10m Roff=1T Vt=0.5 Vh=0.05)
CEFOUT O1 0 10u IC=10.9
Rload1 O1 0 2.2
.ic V(VOUT)=11 V(O1)=10.9
.tran 50n 2m 0 100n uic
.options reltol=0.0001 abstol=1n method=gear
.meas tran BUS_PEAK MAX V(VOUT) FROM=1m TO=2m
.meas tran O1_PEAK MAX V(O1) FROM=1m TO=2m
.meas tran PHASE_CURRENT MAX I(Lfault) FROM=1m TO=2m
.end
