* G1 average model case; non-silicon controller approximations.
.param CBIAS=0.526428409091 LFACTOR=1
.include pdu-inductor-ng.lib
* AUTO-GENERATED from Konnect pdu-current.net; no KiCad source parsing.
* Includes every component and exported pin. ICs/discretes are approximations.
.include pdu-behavioral.lib
CBIN1 VIN 0 1e-08
CBIN2 VIN 0 1e-08
CBOOT1 Net__CBOOT1_Pad1_ SW4_PH1 4.7e-08
CBOOT2 Net__CBOOT2_Pad1_ SW4_PH2 4.7e-08
CCOMP COMP_MID 0 4.7e-09
CDVDT1 DVDT_O1 0 1e-09
CDVDT2 DVDT_S2E 0 1e-09
CEFIN1 VOUT 0 1e-07
CEFIN2 VOUT 0 1e-07
CEFOUT1 O1_11V 0 1e-05
CEFOUT2 S2E_11V 0 1e-05
CHF COMP 0 4.7e-11
CIN1 VIN 0 4.7e-06
CIN2 VIN 0 4.7e-06
CIN3 VIN 0 4.7e-06
CIN4 VIN 0 4.7e-06
CIN5 VIN 0 4.7e-06
CIN6 VIN 0 4.7e-06
CIN7 VIN 0 4.7e-06
CIN8 VIN 0 4.7e-06
CIN_U5 ANODE 0 2.2e-08
COUT1 VOUT 0 {2.2e-05*CBIAS}
COUT2 VOUT 0 {2.2e-05*CBIAS}
COUT3 VOUT 0 {2.2e-05*CBIAS}
COUT4 VOUT 0 {2.2e-05*CBIAS}
COUT5 VOUT 0 {2.2e-05*CBIAS}
COUT6 VOUT 0 {2.2e-05*CBIAS}
COUT7 VOUT 0 {2.2e-05*CBIAS}
COUT8 VOUT 0 {2.2e-05*CBIAS}
CVCAP VCAP ANODE 1e-07
CVCC1 VCC1 0 4.7e-06
CVCC2 VCC2 0 4.7e-06
CVDDA1 VDDA1 0 1e-07
CVDDA2 VDDA2 0 1e-07
D1 0 VIN PDU_TVS
D2 0 O1_11V PDU_SCHOTTKY
D3 0 S2E_11V PDU_SCHOTTKY
R_F1 VBAT ANODE 10m
* PORT J1 2=0 1=VBAT
* PORT J2 2=0 1=O1_11V
* PORT J3 2=0 1=S2E_11V
XL1 SW_PH1 ISNS1 PDU_L LVAL=6.8e-06
XL2 SW_PH2 ISNS2 PDU_L LVAL=6.8e-06
XQ1 ANODE ANODE ANODE GATE VIN PDU_Q1
RBOOT1 Net__CBOOT1_Pad1_ CBOOT1 1
RBOOT2 Net__CBOOT2_Pad1_ CBOOT2 1
RCFG1 CFG_PRI 0 54900
RCFG2 CFG_SEC 0 90900
RCOMP COMP COMP_MID 10010
REN1 VOUT EN_EFUSE 64900
REN2 EN_EFUSE 0 10000
RFB1 VOUT FB 130000
RFB2 FB 0 10200
RILIM1 ILIM_O1 0 301
RILIM2 ILIM_S2E 0 604
RIMON1 IMON_O1 0 806
RIMON2 IMON_S2E 0 806
RPG1 PG_O1 O1_11V 100000
RPG1B PG_O1 0 18000
RPG2 PG_S2E S2E_11V 100000
RPG2B PG_S2E 0 18000
RS1 ISNS1 VOUT 0.0075
RS2 ISNS2 VOUT 0.0075
RSYNC SYNC VDDA1 100000
RT1 RT_PH1 0 49900
RT2 RT_PH2 0 49900
RUV1 VIN EN_BUCK 174000
RUV2 EN_BUCK 0 10000
XU1 VIN VIN VIN CBOOT1 SW4_PH1 VOUT SYNC 0 EN_BUCK unconnected__U1_NC_Pad10_ ISNS1 VOUT CFG_PRI RT_PH1 COMP FB 0 VDDA1 VCC1 SW_PH1 SW_PH1 SW_PH1 0 0 0 0 VIN VIN VIN 0 PDU_BUCK MAIN=1 RSVAL=0.0075
XU2 VIN VIN VIN CBOOT2 SW4_PH2 VOUT unconnected__U2_PG_slash_SYNCOUT_Pad7_ SYNC EN_BUCK unconnected__U2_NC_Pad10_ ISNS2 VOUT CFG_SEC RT_PH2 COMP 0 0 VDDA2 VCC2 SW_PH2 SW_PH2 SW_PH2 0 0 0 0 VIN VIN VIN 0 PDU_BUCK MAIN=0 RSVAL=0.0075
XU3 VOUT VOUT VOUT 0 0 EN_EFUSE unconnected__U3_ITIMER_Pad7_ ILIM_O1 IMON_O1 0 0 0 PG_O1 0 DVDT_O1 VOUT O1_11V O1_11V O1_11V O1_11V O1_11V O1_11V O1_11V O1_11V VOUT 0 PDU_EFUSE RLIM=301
XU4 VOUT VOUT VOUT 0 0 EN_EFUSE unconnected__U4_ITIMER_Pad7_ ILIM_S2E IMON_S2E 0 0 0 PG_S2E 0 DVDT_S2E VOUT S2E_11V S2E_11V S2E_11V S2E_11V S2E_11V S2E_11V S2E_11V S2E_11V VOUT 0 PDU_EFUSE RLIM=604
XU5 VCAP 0 ANODE VIN GATE ANODE PDU_IDEAL_DIODE

Vbattery VBAT 0 PWL(0 0 100u 20)
Bload1 O1_11V 0 I=if(time<10m,0.45,if(time<20m,4.5,0.45))*min(max(V(O1_11V)/5,0),1)
Bload2 S2E_11V 0 I=if(time<10m,0.30,if(time<20m,2.5,0.30))*min(max(V(S2E_11V)/5,0),1)
Rbleed VOUT 0 100k
.tran 1u 30m 0 2u uic
.options reltol=0.0001 abstol=1n method=gear
.meas tran BUS_MIN MIN V(VOUT) FROM=10m TO=12m
.meas tran BUS_MAX MAX V(VOUT) FROM=10m TO=12m
.meas tran O1_PEAK MAX V(O1_11V) FROM=10m TO=20m
.meas tran BUS_RECOVER AVG V(VOUT) FROM=25m TO=29m
.end
