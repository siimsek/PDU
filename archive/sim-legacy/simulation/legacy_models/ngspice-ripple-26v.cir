* IDA PDU 26 V ripple check for ngspice-47. Not an LM70880 model.
Vsw sws 0 PULSE(0 26 0 20n 20n 0.961538u 2.272727u)
Rsw sws sw 50m
L1 sw n1 6.8u IC=3.75
Rdcr n1 out 23.3m
Cout out 0 88u IC=10.85
Rload out 0 2.93333
.tran 10n 300u 0 10n uic
.meas tran VOUT_AVG AVG V(out) FROM=250u TO=300u
.meas tran VOUT_PP PP V(out) FROM=250u TO=300u
.meas tran IL_PP PP I(L1) FROM=250u TO=300u
.meas tran IL_AVG AVG I(L1) FROM=250u TO=300u
.options method=gear
.end
