* PDU full-connectivity BEHAVIORAL bench: reverse; NOT vendor silicon.
.include pdu-circuit.inc
.include pdu-inductor-ng.lib
.param CBIAS=0.5 LFACTOR=1
Vbattery VBAT 0 PWL(0 0 100u -26)
Bload1 O1_11V 0 I=(0)*min(max(V(O1_11V)/5,0),1)
Bload2 S2E_11V 0 I=(0)*min(max(V(S2E_11V)/5,0),1)
Rbleed VOUT 0 100k

.tran 100n 40m 0 1u uic
.options reltol=0.0001 abstol=1n method=gear
Bmeasure1 M_ISNS1 0 V=V(ISNS1,VOUT)/0.0075
Bmeasure2 M_ISNS2 0 V=V(ISNS2,VOUT)/0.0075
.meas tran VIN_MAX MAX V(VIN) FROM=1m TO=40m
.meas tran BUS_MAX MAX V(VOUT) FROM=1m TO=40m
.meas tran IBAT_MAX MAX I(Vbattery) FROM=1m TO=40m
.options plotwinsize=0
.save I(Vbattery) V(VIN) V(VOUT)
.end
