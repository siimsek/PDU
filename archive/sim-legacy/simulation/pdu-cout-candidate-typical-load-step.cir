* PDU full-connectivity BEHAVIORAL bench: cout-candidate-typical-load-step; NOT vendor silicon.
.include pdu-circuit.inc
.include pdu-inductor-lt.lib
.param CBIAS=0.9373721590909091 LFACTOR=1
Vbattery VBAT 0 PWL(0 0 100u 20)
Bload1 O1_11V 0 I=(if(time<20m,0.3,3))*min(max(V(O1_11V)/5,0),1)
Bload2 S2E_11V 0 I=(if(time<20m,0.15,1.5))*min(max(V(S2E_11V)/5,0),1)
Rbleed VOUT 0 100k

.tran 100n 40m 0 1u uic
.options reltol=0.0001 abstol=1n method=gear
Bmeasure1 M_ISNS1 0 V=V(ISNS1,VOUT)/0.0075
Bmeasure2 M_ISNS2 0 V=V(ISNS2,VOUT)/0.0075
.meas tran BUS_MIN MIN V(VOUT) FROM=20m TO=22m
.meas tran BUS_MAX MAX V(VOUT) FROM=20m TO=22m
.meas tran O1_FINAL AVG V(O1_11V) FROM=35m TO=40m
.meas tran S2E_FINAL AVG V(S2E_11V) FROM=35m TO=40m
.options plotwinsize=0
.save V(O1_11V) V(S2E_11V) V(VOUT)
.end
