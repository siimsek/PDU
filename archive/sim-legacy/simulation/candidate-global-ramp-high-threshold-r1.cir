* CANDIDATE ONLY: global two PARALLEL same-direction CSD18534Q5A approximations.
* Actual ADI native LTC4365-1; exact installed symbol port order verified.
* Not a whole converter or qualified TI transistor model. No PCB approval.
.lib "C:\Users\SK\AppData\Local\LTspice\lib\sub\LTC4365-1.sub"
.temp 25
Vsource RAW 0 PWL(0 0 100u 11 30m 11 30.1m 18 45m 18 45.1m 11 50m 11 50.1m 0 55m 0 55.1m 11)
Rovt RAW OV_RAW 219218.99999999997
Rovb OV_RAW 0 9990.0
Voffset OV_RAW OV 0.0075
Ileak OV 0 1e-08
Ruv RAW UV 100k
Rsh RAW SHDN 100k
Xcontroller 0 OV UV RAW GATE OUT FAULT SHDN LTC4365-1
Rfault RAW FAULT 100k
Rg1 GATE GM1 10
Rg2 GATE GM2 10
Vsense1 RAW D1 0
Vsense2 RAW D2 0
Mpass1 D1 GM1 OUT OUT QN W=1 L=1
Mpass2 D2 GM2 OUT OUT QN W=1 L=1
Cgs1 GM1 OUT 4e-09
Cgs2 GM2 OUT 4e-09
Cgd1 GM1 RAW 250p
Cgd2 GM2 RAW 250p
.model QN NMOS(Level=1 VTO=2.3 KP=200 RD=0.005 RS=0.005 TNOM=25)
* Small intrinsic capacitance maximizes startup inrush; larger is an OFF stress.
Iup_stress RAW GATE 0
Rsoft GATE SOFT 5.1k
Csoft SOFT 0 1e-08
Cin RAW 0 100n
* Equivalent of2 equal parallel330u25V polymer branches with explicit ESR.
Rbulk OUT CAP 0.007
Cbulk CAP 0 0.0004224
Bload OUT 0 I=(4.5)*min(max(V(OUT)/5,0),1)
Rbleed OUT 0 100k
.tran 100n 80m 0 250n uic
.options reltol=.0001 plotwinsize=0
.meas tran NORMAL AVG V(OUT) FROM=24m TO=29m
.meas tran PEAK MAX V(OUT) FROM=29m TO=45m
.meas tran RAWPEAK MAX V(RAW) FROM=29m TO=45m
.meas tran VDSPEAK MAX V(RAW,OUT) FROM=29m TO=45m
.meas tran VGS_MIN MIN V(GM1,OUT) FROM=24m TO=29m
.meas tran VGS_MAX MAX V(GM1,OUT) FROM=0 TO=80m
.meas tran RESET AVG V(OUT) FROM=75m TO=80m
.meas tran INRUSH MAX I(Cbulk) FROM=0 TO=24m
.meas tran MOS1_I MAX I(Vsense1) FROM=0 TO=24m
.meas tran MOS1_P MAX (V(D1,OUT)*I(Vsense1)) FROM=0 TO=24m
.meas tran MOS1_E INTEG (V(D1,OUT)*I(Vsense1)) FROM=0 TO=24m
.save V(RAW) V(OUT) V(GATE) V(GM1) V(GM2) V(OV) V(D1) I(Vsense1) I(Vsense2) I(Cbulk)
.end
