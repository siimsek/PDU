* PDU full-connectivity BEHAVIORAL bench: uvlo-falling; NOT vendor silicon.
.include pdu-circuit.inc
.include pdu-inductor-lt.lib
.param CBIAS=0.5 LFACTOR=1
Vbattery VBAT 0 PWL(0 0 100u 20 10m 20 10.1m 18 20m 18 20.1m 16)
Bload1 O1_11V 0 I=(3)*min(max(V(O1_11V)/5,0),1)
Bload2 S2E_11V 0 I=(1.5)*min(max(V(S2E_11V)/5,0),1)
Rbleed VOUT 0 100k

.tran 100n 40m 0 1u uic
.options reltol=0.0001 abstol=1n method=gear
Bmeasure1 M_ISNS1 0 V=V(ISNS1,VOUT)/0.0075
Bmeasure2 M_ISNS2 0 V=V(ISNS2,VOUT)/0.0075
.meas tran BUS_HOLD AVG V(VOUT) FROM=16m TO=19m
.meas tran BUS_OFF MAX V(VOUT) FROM=30m TO=40m
.options plotwinsize=0
.save V(VOUT)
.end
