* Two actual parallel phases, 180 degrees; ideal PWM, NOT TI controller.
.param CBIAS=.5 LFACTOR=1
.include pdu-behavioral.lib
.include pdu-inductor-ng.lib
Vsw1 drive1 0 PULSE(0 26 0 20n 20n 9.78881991327e-07 2.2985e-06)
Vsw2 drive2 0 PULSE(0 26 1.14925e-06 20n 20n 9.78881991327e-07 2.2985e-06)
Rsw1 drive1 SW_PH1 50m
Rsw2 drive2 SW_PH2 50m
XL1 SW_PH1 ISNS1 PDU_L LVAL=6.8e-06
XL2 SW_PH2 ISNS2 PDU_L LVAL=6.8e-06
RS1 ISNS1 VOUT 0.0075
RS2 ISNS2 VOUT 0.0075
Bmeasure1 M_ISNS1 0 V=V(ISNS1,VOUT)/0.0075
Bmeasure2 M_ISNS2 0 V=V(ISNS2,VOUT)/0.0075
COUT1 VOUT 0 {2.2e-05*CBIAS}
COUT2 VOUT 0 {2.2e-05*CBIAS}
COUT3 VOUT 0 {2.2e-05*CBIAS}
COUT4 VOUT 0 {2.2e-05*CBIAS}
COUT5 VOUT 0 {2.2e-05*CBIAS}
COUT6 VOUT 0 {2.2e-05*CBIAS}
COUT7 VOUT 0 {2.2e-05*CBIAS}
COUT8 VOUT 0 {2.2e-05*CBIAS}
Rload VOUT 0 1.46614379085
.ic V(VOUT)=10.996078431372549
.tran 1n 0.0022985 0 1n uic
.options method=gear reltol=0.0001
.meas tran BUS_AVG AVG V(VOUT) FROM=0.0018388 TO=0.0022985
.meas tran BUS_PP PP V(VOUT) FROM=0.0018388 TO=0.0022985
.meas tran I1_AVG AVG V(M_ISNS1) FROM=0.0018388 TO=0.0022985
.meas tran I2_AVG AVG V(M_ISNS2) FROM=0.0018388 TO=0.0022985
.meas tran I1_PP PP V(M_ISNS1) FROM=0.0018388 TO=0.0022985
.meas tran I2_PP PP V(M_ISNS2) FROM=0.0018388 TO=0.0022985
.meas tran PHASE_DELAY TRIG V(drive1) VAL=13.0 RISE=2 TARG V(drive2) VAL=13.0 RISE=2
.options plotwinsize=0
.save V(M_ISNS1) V(M_ISNS2) V(VOUT) V(drive1) V(drive2)
.end
